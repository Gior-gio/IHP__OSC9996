*********************************************************
*** NGSPICE file created by KLayout-PEX 0.3.7
*** -----------------------------------------------------
***     Extraction Engine: KPEX/2.5D
***     Technology: ihp_sg13g2
***     Date: 2026-03-05 19:27:23
*********************************************************

.SUBCKT LIF_neuron VDD SPIKE RST MEM VSS Vx Vref
xM$1 VSS \$9 \$8 VSS sg13_lv_nmos L=0.13U W=1U AS=0.34P AD=0.19P PS=2.68U
+ PD=1.38U
xM$2 \$44 \$10 VSS VSS sg13_lv_nmos L=0.13U W=1U AS=0.19P AD=0.19P PS=1.38U
+ PD=1.38U
xM$3 \$9 \$15 \$44 VSS sg13_lv_nmos L=0.13U W=1U AS=0.19P AD=0.34P PS=1.38U
+ PD=2.68U
xM$4 VSS \$11 \$10 VSS sg13_lv_nmos L=0.65U W=1U AS=0.34P AD=0.34P PS=2.68U
+ PD=2.68U
xM$5 VSS \$12 \$11 VSS sg13_lv_nmos L=0.65U W=1U AS=0.34P AD=0.34P PS=2.68U
+ PD=2.68U
xM$6 VSS \$13 \$12 VSS sg13_lv_nmos L=0.65U W=1U AS=0.34P AD=0.34P PS=2.68U
+ PD=2.68U
xM$7 VSS \$14 \$13 VSS sg13_lv_nmos L=0.65U W=1U AS=0.34P AD=0.34P PS=2.68U
+ PD=2.68U
xM$8 VSS \$15 \$14 VSS sg13_lv_nmos L=0.65U W=1U AS=0.34P AD=0.34P PS=2.68U
+ PD=2.68U
xM$9 VSS \$4 \$3 VSS sg13_lv_nmos L=0.13U W=1U AS=0.34P AD=0.19P PS=2.68U
+ PD=1.38U
xM$10 \$3 \$4 VSS VSS sg13_lv_nmos L=0.13U W=1U AS=0.19P AD=0.19P PS=1.38U
+ PD=1.38U
xM$11 VSS \$4 \$3 VSS sg13_lv_nmos L=0.13U W=1U AS=0.19P AD=0.34P PS=1.38U
+ PD=2.68U
xM$12 VSS \$5 \$4 VSS sg13_lv_nmos L=0.13U W=1U AS=0.34P AD=0.34P PS=2.68U
+ PD=2.68U
xM$13 VSS \$41 \$5 VSS sg13_lv_nmos L=0.13U W=1U AS=0.34P AD=0.19P PS=2.68U
+ PD=1.38U
xM$14 \$41 \$15 VSS VSS sg13_lv_nmos L=0.13U W=1U AS=0.19P AD=0.19P PS=1.38U
+ PD=1.38U
xM$15 VSS RST \$41 VSS sg13_lv_nmos L=0.13U W=1U AS=0.19P AD=0.34P PS=1.38U
+ PD=2.68U
xM$16 VSS \$7 SPIKE VSS sg13_lv_nmos L=0.13U W=1U AS=0.34P AD=0.19P PS=2.68U
+ PD=1.38U
xM$17 SPIKE \$7 VSS VSS sg13_lv_nmos L=0.13U W=1U AS=0.19P AD=0.19P PS=1.38U
+ PD=1.38U
xM$18 VSS \$7 SPIKE VSS sg13_lv_nmos L=0.13U W=1U AS=0.19P AD=0.34P PS=1.38U
+ PD=2.68U
xM$19 VSS \$8 \$7 VSS sg13_lv_nmos L=0.13U W=1U AS=0.34P AD=0.34P PS=2.68U
+ PD=2.68U
xM$20 \$15 \$16 VSS VSS sg13_lv_nmos L=0.13U W=1U AS=0.34P AD=0.19P PS=2.68U
+ PD=1.38U
xM$21 VSS \$16 \$15 VSS sg13_lv_nmos L=0.13U W=1U AS=0.19P AD=0.19P PS=1.38U
+ PD=1.38U
xM$22 \$16 MEM VSS VSS sg13_lv_nmos L=0.13U W=1U AS=0.19P AD=0.19P PS=1.38U
+ PD=1.38U
xM$23 VSS MEM \$16 VSS sg13_lv_nmos L=0.13U W=1U AS=0.19P AD=0.34P PS=1.38U
+ PD=2.68U
xM$24 \$138 Vref VSS VSS sg13_lv_nmos L=0.13U W=1U AS=0.34P AD=0.34P PS=2.68U
+ PD=2.68U
xM$25 \$130 VSS VSS VSS sg13_lv_nmos L=0.13U W=1U AS=0.34P AD=0.19P PS=2.68U
+ PD=1.38U
xM$26 \$166 \$164 \$130 VSS sg13_lv_nmos L=0.13U W=1U AS=0.19P AD=0.19P PS=1.38U
+ PD=1.38U
xM$27 VSS Vx \$166 VSS sg13_lv_nmos L=0.13U W=1U AS=0.19P AD=0.34P PS=1.38U
+ PD=2.68U
xM$28 \$76 \$3 VSS VSS sg13_lv_nmos L=0.13U W=1U AS=0.34P AD=0.19P PS=2.68U
+ PD=1.38U
xM$29 \$45 \$130 \$76 VSS sg13_lv_nmos L=0.13U W=1U AS=0.19P AD=0.19P PS=1.38U
+ PD=1.38U
xM$30 VSS Vx \$45 VSS sg13_lv_nmos L=0.13U W=1U AS=0.19P AD=0.34P PS=1.38U
+ PD=2.68U
xM$31 \$100 VSS VSS VSS sg13_lv_nmos L=0.13U W=1U AS=0.34P AD=0.19P PS=2.68U
+ PD=1.38U
xM$32 \$171 \$165 \$100 VSS sg13_lv_nmos L=0.13U W=1U AS=0.19P AD=0.19P PS=1.38U
+ PD=1.38U
xM$33 VSS Vref \$171 VSS sg13_lv_nmos L=0.13U W=1U AS=0.19P AD=0.34P PS=1.38U
+ PD=2.68U
xM$34 \$46 \$3 VSS VSS sg13_lv_nmos L=0.13U W=1U AS=0.34P AD=0.19P PS=2.68U
+ PD=1.38U
xM$35 \$47 \$100 \$46 VSS sg13_lv_nmos L=0.13U W=1U AS=0.19P AD=0.19P PS=1.38U
+ PD=1.38U
xM$36 VSS Vref \$47 VSS sg13_lv_nmos L=0.13U W=1U AS=0.19P AD=0.34P PS=1.38U
+ PD=2.68U
xM$37 \$48 \$46 VSS VSS sg13_lv_nmos L=0.13U W=1U AS=0.34P AD=0.34P PS=2.68U
+ PD=2.68U
xM$38 \$132 \$100 VSS VSS sg13_lv_nmos L=0.13U W=1U AS=0.34P AD=0.34P PS=2.68U
+ PD=2.68U
xM$39 \$77 \$76 VSS VSS sg13_lv_nmos L=0.13U W=1U AS=0.34P AD=0.34P PS=2.68U
+ PD=2.68U
xM$40 \$133 \$130 VSS VSS sg13_lv_nmos L=0.13U W=1U AS=0.34P AD=0.34P PS=2.68U
+ PD=2.68U
xM$41 \$172 \$100 VSS VSS sg13_lv_nmos L=0.13U W=1U AS=0.34P AD=0.19P PS=2.68U
+ PD=1.38U
xM$42 \$135 \$130 \$172 VSS sg13_lv_nmos L=0.13U W=1U AS=0.19P AD=0.19P PS=1.38U
+ PD=1.38U
xM$43 \$167 \$133 \$135 VSS sg13_lv_nmos L=0.13U W=1U AS=0.19P AD=0.19P PS=1.38U
+ PD=1.38U
xM$44 VSS \$132 \$167 VSS sg13_lv_nmos L=0.13U W=1U AS=0.19P AD=0.34P PS=1.38U
+ PD=2.68U
xM$45 \$49 \$46 VSS VSS sg13_lv_nmos L=0.13U W=1U AS=0.34P AD=0.19P PS=2.68U
+ PD=1.38U
xM$46 \$50 \$76 \$49 VSS sg13_lv_nmos L=0.13U W=1U AS=0.19P AD=0.19P PS=1.38U
+ PD=1.38U
xM$47 \$51 \$77 \$50 VSS sg13_lv_nmos L=0.13U W=1U AS=0.19P AD=0.19P PS=1.38U
+ PD=1.38U
xM$48 VSS \$48 \$51 VSS sg13_lv_nmos L=0.13U W=1U AS=0.19P AD=0.34P PS=1.38U
+ PD=2.68U
xM$49 \$140 \$135 VSS VSS sg13_lv_nmos L=0.13U W=1U AS=0.34P AD=0.34P PS=2.68U
+ PD=2.68U
xM$50 \$78 \$50 VSS VSS sg13_lv_nmos L=0.13U W=1U AS=0.34P AD=0.34P PS=2.68U
+ PD=2.68U
xM$51 \$137 \$140 VSS VSS sg13_lv_nmos L=0.13U W=1U AS=0.34P AD=0.19P PS=2.68U
+ PD=1.38U
xM$52 VSS \$140 \$137 VSS sg13_lv_nmos L=0.13U W=1U AS=0.19P AD=0.19P PS=1.38U
+ PD=1.38U
xM$53 \$137 \$140 VSS VSS sg13_lv_nmos L=0.13U W=1U AS=0.19P AD=0.34P PS=1.38U
+ PD=2.68U
xM$54 \$52 \$78 VSS VSS sg13_lv_nmos L=0.13U W=1U AS=0.34P AD=0.19P PS=2.68U
+ PD=1.38U
xM$55 VSS \$78 \$52 VSS sg13_lv_nmos L=0.13U W=1U AS=0.19P AD=0.19P PS=1.38U
+ PD=1.38U
xM$56 \$52 \$78 VSS VSS sg13_lv_nmos L=0.13U W=1U AS=0.19P AD=0.34P PS=1.38U
+ PD=2.68U
xM$57 \$196 Vx VSS VSS sg13_lv_nmos L=0.13U W=1U AS=0.34P AD=0.34P PS=2.68U
+ PD=2.68U
xM$58 \$164 \$3 VSS VSS sg13_lv_nmos L=0.13U W=1U AS=0.34P AD=0.19P PS=2.68U
+ PD=1.38U
xM$59 \$176 \$223 \$164 VSS sg13_lv_nmos L=0.13U W=1U AS=0.19P AD=0.19P PS=1.38U
+ PD=1.38U
xM$60 VSS Vx \$176 VSS sg13_lv_nmos L=0.13U W=1U AS=0.19P AD=0.34P PS=1.38U
+ PD=2.68U
xM$61 \$165 \$3 VSS VSS sg13_lv_nmos L=0.13U W=1U AS=0.34P AD=0.19P PS=2.68U
+ PD=1.38U
xM$62 \$197 \$255 \$165 VSS sg13_lv_nmos L=0.13U W=1U AS=0.19P AD=0.19P PS=1.38U
+ PD=1.38U
xM$63 VSS Vref \$197 VSS sg13_lv_nmos L=0.13U W=1U AS=0.19P AD=0.34P PS=1.38U
+ PD=2.68U
xM$64 \$198 \$165 VSS VSS sg13_lv_nmos L=0.13U W=1U AS=0.34P AD=0.34P PS=2.68U
+ PD=2.68U
xM$65 \$199 \$164 VSS VSS sg13_lv_nmos L=0.13U W=1U AS=0.34P AD=0.34P PS=2.68U
+ PD=2.68U
xM$66 \$177 \$165 VSS VSS sg13_lv_nmos L=0.13U W=1U AS=0.34P AD=0.19P PS=2.68U
+ PD=1.38U
xM$67 \$178 \$164 \$177 VSS sg13_lv_nmos L=0.13U W=1U AS=0.19P AD=0.19P PS=1.38U
+ PD=1.38U
xM$68 \$200 \$199 \$178 VSS sg13_lv_nmos L=0.13U W=1U AS=0.19P AD=0.19P PS=1.38U
+ PD=1.38U
xM$69 VSS \$198 \$200 VSS sg13_lv_nmos L=0.13U W=1U AS=0.19P AD=0.34P PS=1.38U
+ PD=2.68U
xM$70 \$201 \$178 VSS VSS sg13_lv_nmos L=0.13U W=1U AS=0.34P AD=0.34P PS=2.68U
+ PD=2.68U
xM$71 \$202 \$201 VSS VSS sg13_lv_nmos L=0.13U W=1U AS=0.34P AD=0.19P PS=2.68U
+ PD=1.38U
xM$72 VSS \$201 \$202 VSS sg13_lv_nmos L=0.13U W=1U AS=0.19P AD=0.19P PS=1.38U
+ PD=1.38U
xM$73 \$202 \$201 VSS VSS sg13_lv_nmos L=0.13U W=1U AS=0.19P AD=0.34P PS=1.38U
+ PD=2.68U
xM$74 \$223 VSS VSS VSS sg13_lv_nmos L=0.13U W=1U AS=0.34P AD=0.19P PS=2.68U
+ PD=1.38U
xM$75 \$291 \$286 \$223 VSS sg13_lv_nmos L=0.13U W=1U AS=0.19P AD=0.19P PS=1.38U
+ PD=1.38U
xM$76 VSS Vx \$291 VSS sg13_lv_nmos L=0.13U W=1U AS=0.19P AD=0.34P PS=1.38U
+ PD=2.68U
xM$77 \$286 \$3 VSS VSS sg13_lv_nmos L=0.13U W=1U AS=0.34P AD=0.19P PS=2.68U
+ PD=1.38U
xM$78 \$317 \$76 \$286 VSS sg13_lv_nmos L=0.13U W=1U AS=0.19P AD=0.19P PS=1.38U
+ PD=1.38U
xM$79 VSS Vx \$317 VSS sg13_lv_nmos L=0.13U W=1U AS=0.19P AD=0.34P PS=1.38U
+ PD=2.68U
xM$80 \$255 VSS VSS VSS sg13_lv_nmos L=0.13U W=1U AS=0.34P AD=0.19P PS=2.68U
+ PD=1.38U
xM$81 \$292 \$287 \$255 VSS sg13_lv_nmos L=0.13U W=1U AS=0.19P AD=0.19P PS=1.38U
+ PD=1.38U
xM$82 VSS Vref \$292 VSS sg13_lv_nmos L=0.13U W=1U AS=0.19P AD=0.34P PS=1.38U
+ PD=2.68U
xM$83 \$287 \$3 VSS VSS sg13_lv_nmos L=0.13U W=1U AS=0.34P AD=0.19P PS=2.68U
+ PD=1.38U
xM$84 \$298 \$46 \$287 VSS sg13_lv_nmos L=0.13U W=1U AS=0.19P AD=0.19P PS=1.38U
+ PD=1.38U
xM$85 VSS Vref \$298 VSS sg13_lv_nmos L=0.13U W=1U AS=0.19P AD=0.34P PS=1.38U
+ PD=2.68U
xM$86 \$261 \$255 VSS VSS sg13_lv_nmos L=0.13U W=1U AS=0.34P AD=0.34P PS=2.68U
+ PD=2.68U
xM$87 \$318 \$287 VSS VSS sg13_lv_nmos L=0.13U W=1U AS=0.34P AD=0.34P PS=2.68U
+ PD=2.68U
xM$88 \$319 \$286 VSS VSS sg13_lv_nmos L=0.13U W=1U AS=0.34P AD=0.34P PS=2.68U
+ PD=2.68U
xM$89 \$262 \$223 VSS VSS sg13_lv_nmos L=0.13U W=1U AS=0.34P AD=0.34P PS=2.68U
+ PD=2.68U
xM$90 \$293 \$255 VSS VSS sg13_lv_nmos L=0.13U W=1U AS=0.34P AD=0.19P PS=2.68U
+ PD=1.38U
xM$91 \$258 \$223 \$293 VSS sg13_lv_nmos L=0.13U W=1U AS=0.19P AD=0.19P PS=1.38U
+ PD=1.38U
xM$92 \$294 \$262 \$258 VSS sg13_lv_nmos L=0.13U W=1U AS=0.19P AD=0.19P PS=1.38U
+ PD=1.38U
xM$93 VSS \$261 \$294 VSS sg13_lv_nmos L=0.13U W=1U AS=0.19P AD=0.34P PS=1.38U
+ PD=2.68U
xM$94 \$320 \$287 VSS VSS sg13_lv_nmos L=0.13U W=1U AS=0.34P AD=0.19P PS=2.68U
+ PD=1.38U
xM$95 \$321 \$286 \$320 VSS sg13_lv_nmos L=0.13U W=1U AS=0.19P AD=0.19P PS=1.38U
+ PD=1.38U
xM$96 \$299 \$319 \$321 VSS sg13_lv_nmos L=0.13U W=1U AS=0.19P AD=0.19P PS=1.38U
+ PD=1.38U
xM$97 VSS \$318 \$299 VSS sg13_lv_nmos L=0.13U W=1U AS=0.19P AD=0.34P PS=1.38U
+ PD=2.68U
xM$98 \$263 \$258 VSS VSS sg13_lv_nmos L=0.13U W=1U AS=0.34P AD=0.34P PS=2.68U
+ PD=2.68U
xM$99 \$322 \$321 VSS VSS sg13_lv_nmos L=0.13U W=1U AS=0.34P AD=0.34P PS=2.68U
+ PD=2.68U
xM$100 \$300 \$322 VSS VSS sg13_lv_nmos L=0.13U W=1U AS=0.34P AD=0.19P PS=2.68U
+ PD=1.38U
xM$101 VSS \$322 \$300 VSS sg13_lv_nmos L=0.13U W=1U AS=0.19P AD=0.19P PS=1.38U
+ PD=1.38U
xM$102 \$300 \$322 VSS VSS sg13_lv_nmos L=0.13U W=1U AS=0.19P AD=0.34P PS=1.38U
+ PD=2.68U
xM$103 \$260 \$263 VSS VSS sg13_lv_nmos L=0.13U W=1U AS=0.34P AD=0.19P PS=2.68U
+ PD=1.38U
xM$104 VSS \$263 \$260 VSS sg13_lv_nmos L=0.13U W=1U AS=0.19P AD=0.19P PS=1.38U
+ PD=1.38U
xM$105 \$260 \$263 VSS VSS sg13_lv_nmos L=0.13U W=1U AS=0.19P AD=0.34P PS=1.38U
+ PD=2.68U
xM$106 VDD \$4 \$3 VDD sg13_lv_pmos L=0.13U W=2U AS=0.68P AD=0.38P PS=4.68U
+ PD=2.38U
xM$107 \$3 \$4 VDD VDD sg13_lv_pmos L=0.13U W=2U AS=0.38P AD=0.38P PS=2.38U
+ PD=2.38U
xM$108 VDD \$4 \$3 VDD sg13_lv_pmos L=0.13U W=2U AS=0.38P AD=0.68P PS=2.38U
+ PD=4.68U
xM$109 VDD \$5 \$4 VDD sg13_lv_pmos L=0.13U W=2U AS=0.68P AD=0.68P PS=4.68U
+ PD=4.68U
xM$110 VDD \$41 \$5 VDD sg13_lv_pmos L=0.13U W=2U AS=0.68P AD=0.38P PS=4.68U
+ PD=2.38U
xM$111 \$2 \$15 VDD VDD sg13_lv_pmos L=0.13U W=2U AS=0.38P AD=0.38P PS=2.38U
+ PD=2.38U
xM$112 \$41 RST \$2 VDD sg13_lv_pmos L=0.13U W=2U AS=0.38P AD=0.68P PS=2.38U
+ PD=4.68U
xM$113 VDD \$7 SPIKE VDD sg13_lv_pmos L=0.13U W=2U AS=0.68P AD=0.38P PS=4.68U
+ PD=2.38U
xM$114 SPIKE \$7 VDD VDD sg13_lv_pmos L=0.13U W=2U AS=0.38P AD=0.38P PS=2.38U
+ PD=2.38U
xM$115 VDD \$7 SPIKE VDD sg13_lv_pmos L=0.13U W=2U AS=0.38P AD=0.68P PS=2.38U
+ PD=4.68U
xM$116 VDD \$8 \$7 VDD sg13_lv_pmos L=0.13U W=2U AS=0.68P AD=0.68P PS=4.68U
+ PD=4.68U
xM$117 VDD \$9 \$8 VDD sg13_lv_pmos L=0.13U W=2U AS=0.68P AD=0.38P PS=4.68U
+ PD=2.38U
xM$118 \$9 \$10 VDD VDD sg13_lv_pmos L=0.13U W=2U AS=0.38P AD=0.38P PS=2.38U
+ PD=2.38U
xM$119 VDD \$15 \$9 VDD sg13_lv_pmos L=0.13U W=2U AS=0.38P AD=0.68P PS=2.38U
+ PD=4.68U
xM$120 VDD \$11 \$10 VDD sg13_lv_pmos L=0.65U W=2U AS=0.68P AD=0.68P PS=4.68U
+ PD=4.68U
xM$121 VDD \$12 \$11 VDD sg13_lv_pmos L=0.65U W=2U AS=0.68P AD=0.68P PS=4.68U
+ PD=4.68U
xM$122 VDD \$13 \$12 VDD sg13_lv_pmos L=0.65U W=2U AS=0.68P AD=0.68P PS=4.68U
+ PD=4.68U
xM$123 VDD \$14 \$13 VDD sg13_lv_pmos L=0.65U W=2U AS=0.68P AD=0.68P PS=4.68U
+ PD=4.68U
xM$124 VDD \$15 \$14 VDD sg13_lv_pmos L=0.65U W=2U AS=0.68P AD=0.68P PS=4.68U
+ PD=4.68U
xM$125 \$138 \$138 VDD VDD sg13_lv_pmos L=0.13U W=2U AS=0.68P AD=0.68P PS=4.68U
+ PD=4.68U
xM$126 \$130 VDD VDD VDD sg13_lv_pmos L=0.13U W=2U AS=0.68P AD=0.38P PS=4.68U
+ PD=2.38U
xM$127 \$139 \$164 \$130 VDD sg13_lv_pmos L=0.13U W=2U AS=0.38P AD=0.38P
+ PS=2.38U PD=2.38U
xM$128 VDD \$196 \$139 VDD sg13_lv_pmos L=0.13U W=2U AS=0.38P AD=0.68P PS=2.38U
+ PD=4.68U
xM$129 \$76 VDD VDD VDD sg13_lv_pmos L=0.13U W=2U AS=0.68P AD=0.38P PS=4.68U
+ PD=2.38U
xM$130 \$104 \$130 \$76 VDD sg13_lv_pmos L=0.13U W=2U AS=0.38P AD=0.38P PS=2.38U
+ PD=2.38U
xM$131 VDD \$196 \$104 VDD sg13_lv_pmos L=0.13U W=2U AS=0.38P AD=0.68P PS=2.38U
+ PD=4.68U
xM$132 \$100 VDD VDD VDD sg13_lv_pmos L=0.13U W=2U AS=0.68P AD=0.38P PS=4.68U
+ PD=2.38U
xM$133 \$131 \$165 \$100 VDD sg13_lv_pmos L=0.13U W=2U AS=0.38P AD=0.38P
+ PS=2.38U PD=2.38U
xM$134 VDD \$138 \$131 VDD sg13_lv_pmos L=0.13U W=2U AS=0.38P AD=0.68P PS=2.38U
+ PD=4.68U
xM$135 \$46 VDD VDD VDD sg13_lv_pmos L=0.13U W=2U AS=0.68P AD=0.38P PS=4.68U
+ PD=2.38U
xM$136 \$105 \$100 \$46 VDD sg13_lv_pmos L=0.13U W=2U AS=0.38P AD=0.38P PS=2.38U
+ PD=2.38U
xM$137 VDD \$138 \$105 VDD sg13_lv_pmos L=0.13U W=2U AS=0.38P AD=0.68P PS=2.38U
+ PD=4.68U
xM$138 \$48 \$46 VDD VDD sg13_lv_pmos L=0.13U W=2U AS=0.68P AD=0.68P PS=4.68U
+ PD=4.68U
xM$139 \$132 \$100 VDD VDD sg13_lv_pmos L=0.13U W=2U AS=0.68P AD=0.68P PS=4.68U
+ PD=4.68U
xM$140 \$77 \$76 VDD VDD sg13_lv_pmos L=0.13U W=2U AS=0.68P AD=0.68P PS=4.68U
+ PD=4.68U
xM$141 \$133 \$130 VDD VDD sg13_lv_pmos L=0.13U W=2U AS=0.68P AD=0.68P PS=4.68U
+ PD=4.68U
xM$142 \$134 \$100 VDD VDD sg13_lv_pmos L=0.13U W=2U AS=0.68P AD=0.38P PS=4.68U
+ PD=2.38U
xM$143 \$135 \$133 \$134 VDD sg13_lv_pmos L=0.13U W=2U AS=0.38P AD=0.38P
+ PS=2.38U PD=2.38U
xM$144 \$136 \$130 \$135 VDD sg13_lv_pmos L=0.13U W=2U AS=0.38P AD=0.38P
+ PS=2.38U PD=2.38U
xM$145 VDD \$132 \$136 VDD sg13_lv_pmos L=0.13U W=2U AS=0.38P AD=0.68P PS=2.38U
+ PD=4.68U
xM$146 \$106 \$46 VDD VDD sg13_lv_pmos L=0.13U W=2U AS=0.68P AD=0.38P PS=4.68U
+ PD=2.38U
xM$147 \$50 \$77 \$106 VDD sg13_lv_pmos L=0.13U W=2U AS=0.38P AD=0.38P PS=2.38U
+ PD=2.38U
xM$148 \$107 \$76 \$50 VDD sg13_lv_pmos L=0.13U W=2U AS=0.38P AD=0.38P PS=2.38U
+ PD=2.38U
xM$149 VDD \$48 \$107 VDD sg13_lv_pmos L=0.13U W=2U AS=0.38P AD=0.68P PS=2.38U
+ PD=4.68U
xM$150 \$140 \$135 VDD VDD sg13_lv_pmos L=0.13U W=2U AS=0.68P AD=0.68P PS=4.68U
+ PD=4.68U
xM$151 \$78 \$50 VDD VDD sg13_lv_pmos L=0.13U W=2U AS=0.68P AD=0.68P PS=4.68U
+ PD=4.68U
xM$152 \$52 \$78 VDD VDD sg13_lv_pmos L=0.13U W=2U AS=0.68P AD=0.38P PS=4.68U
+ PD=2.38U
xM$153 VDD \$78 \$52 VDD sg13_lv_pmos L=0.13U W=2U AS=0.38P AD=0.38P PS=2.38U
+ PD=2.38U
xM$154 \$52 \$78 VDD VDD sg13_lv_pmos L=0.13U W=2U AS=0.38P AD=0.68P PS=2.38U
+ PD=4.68U
xM$155 \$137 \$140 VDD VDD sg13_lv_pmos L=0.13U W=2U AS=0.68P AD=0.38P PS=4.68U
+ PD=2.38U
xM$156 VDD \$140 \$137 VDD sg13_lv_pmos L=0.13U W=2U AS=0.38P AD=0.38P PS=2.38U
+ PD=2.38U
xM$157 \$137 \$140 VDD VDD sg13_lv_pmos L=0.13U W=2U AS=0.38P AD=0.68P PS=2.38U
+ PD=4.68U
xM$158 \$15 \$16 VDD VDD sg13_lv_pmos L=0.13U W=2U AS=0.68P AD=0.38P PS=4.68U
+ PD=2.38U
xM$159 VDD \$16 \$15 VDD sg13_lv_pmos L=0.13U W=2U AS=0.38P AD=0.38P PS=2.38U
+ PD=2.38U
xM$160 \$16 MEM VDD VDD sg13_lv_pmos L=0.13U W=2U AS=0.38P AD=0.38P PS=2.38U
+ PD=2.38U
xM$161 VDD MEM \$16 VDD sg13_lv_pmos L=0.13U W=2U AS=0.38P AD=0.68P PS=2.38U
+ PD=4.68U
xM$162 \$196 \$196 VDD VDD sg13_lv_pmos L=0.13U W=2U AS=0.68P AD=0.68P PS=4.68U
+ PD=4.68U
xM$163 \$164 VDD VDD VDD sg13_lv_pmos L=0.13U W=2U AS=0.68P AD=0.38P PS=4.68U
+ PD=2.38U
xM$164 \$227 \$223 \$164 VDD sg13_lv_pmos L=0.13U W=2U AS=0.38P AD=0.38P
+ PS=2.38U PD=2.38U
xM$165 VDD \$196 \$227 VDD sg13_lv_pmos L=0.13U W=2U AS=0.38P AD=0.68P PS=2.38U
+ PD=4.68U
xM$166 \$165 VDD VDD VDD sg13_lv_pmos L=0.13U W=2U AS=0.68P AD=0.38P PS=4.68U
+ PD=2.38U
xM$167 \$228 \$255 \$165 VDD sg13_lv_pmos L=0.13U W=2U AS=0.38P AD=0.38P
+ PS=2.38U PD=2.38U
xM$168 VDD \$138 \$228 VDD sg13_lv_pmos L=0.13U W=2U AS=0.38P AD=0.68P PS=2.38U
+ PD=4.68U
xM$169 \$198 \$165 VDD VDD sg13_lv_pmos L=0.13U W=2U AS=0.68P AD=0.68P PS=4.68U
+ PD=4.68U
xM$170 \$199 \$164 VDD VDD sg13_lv_pmos L=0.13U W=2U AS=0.68P AD=0.68P PS=4.68U
+ PD=4.68U
xM$171 \$230 \$165 VDD VDD sg13_lv_pmos L=0.13U W=2U AS=0.68P AD=0.38P PS=4.68U
+ PD=2.38U
xM$172 \$178 \$199 \$230 VDD sg13_lv_pmos L=0.13U W=2U AS=0.38P AD=0.38P
+ PS=2.38U PD=2.38U
xM$173 \$229 \$164 \$178 VDD sg13_lv_pmos L=0.13U W=2U AS=0.38P AD=0.38P
+ PS=2.38U PD=2.38U
xM$174 VDD \$198 \$229 VDD sg13_lv_pmos L=0.13U W=2U AS=0.38P AD=0.68P PS=2.38U
+ PD=4.68U
xM$175 \$201 \$178 VDD VDD sg13_lv_pmos L=0.13U W=2U AS=0.68P AD=0.68P PS=4.68U
+ PD=4.68U
xM$176 \$202 \$201 VDD VDD sg13_lv_pmos L=0.13U W=2U AS=0.68P AD=0.38P PS=4.68U
+ PD=2.38U
xM$177 VDD \$201 \$202 VDD sg13_lv_pmos L=0.13U W=2U AS=0.38P AD=0.38P PS=2.38U
+ PD=2.38U
xM$178 \$202 \$201 VDD VDD sg13_lv_pmos L=0.13U W=2U AS=0.38P AD=0.68P PS=2.38U
+ PD=4.68U
xM$179 \$223 VDD VDD VDD sg13_lv_pmos L=0.13U W=2U AS=0.68P AD=0.38P PS=4.68U
+ PD=2.38U
xM$180 \$254 \$286 \$223 VDD sg13_lv_pmos L=0.13U W=2U AS=0.38P AD=0.38P
+ PS=2.38U PD=2.38U
xM$181 VDD \$196 \$254 VDD sg13_lv_pmos L=0.13U W=2U AS=0.38P AD=0.68P PS=2.38U
+ PD=4.68U
xM$182 \$286 VDD VDD VDD sg13_lv_pmos L=0.13U W=2U AS=0.68P AD=0.38P PS=4.68U
+ PD=2.38U
xM$183 \$345 \$76 \$286 VDD sg13_lv_pmos L=0.13U W=2U AS=0.38P AD=0.38P PS=2.38U
+ PD=2.38U
xM$184 VDD \$196 \$345 VDD sg13_lv_pmos L=0.13U W=2U AS=0.38P AD=0.68P PS=2.38U
+ PD=4.68U
xM$185 \$287 VDD VDD VDD sg13_lv_pmos L=0.13U W=2U AS=0.68P AD=0.38P PS=4.68U
+ PD=2.38U
xM$186 \$347 \$46 \$287 VDD sg13_lv_pmos L=0.13U W=2U AS=0.38P AD=0.38P PS=2.38U
+ PD=2.38U
xM$187 VDD \$138 \$347 VDD sg13_lv_pmos L=0.13U W=2U AS=0.38P AD=0.68P PS=2.38U
+ PD=4.68U
xM$188 \$255 VDD VDD VDD sg13_lv_pmos L=0.13U W=2U AS=0.68P AD=0.38P PS=4.68U
+ PD=2.38U
xM$189 \$256 \$287 \$255 VDD sg13_lv_pmos L=0.13U W=2U AS=0.38P AD=0.38P
+ PS=2.38U PD=2.38U
xM$190 VDD \$138 \$256 VDD sg13_lv_pmos L=0.13U W=2U AS=0.38P AD=0.68P PS=2.38U
+ PD=4.68U
xM$191 \$318 \$287 VDD VDD sg13_lv_pmos L=0.13U W=2U AS=0.68P AD=0.68P PS=4.68U
+ PD=4.68U
xM$192 \$261 \$255 VDD VDD sg13_lv_pmos L=0.13U W=2U AS=0.68P AD=0.68P PS=4.68U
+ PD=4.68U
xM$193 \$262 \$223 VDD VDD sg13_lv_pmos L=0.13U W=2U AS=0.68P AD=0.68P PS=4.68U
+ PD=4.68U
xM$194 \$319 \$286 VDD VDD sg13_lv_pmos L=0.13U W=2U AS=0.68P AD=0.68P PS=4.68U
+ PD=4.68U
xM$195 \$257 \$255 VDD VDD sg13_lv_pmos L=0.13U W=2U AS=0.68P AD=0.38P PS=4.68U
+ PD=2.38U
xM$196 \$258 \$262 \$257 VDD sg13_lv_pmos L=0.13U W=2U AS=0.38P AD=0.38P
+ PS=2.38U PD=2.38U
xM$197 \$259 \$223 \$258 VDD sg13_lv_pmos L=0.13U W=2U AS=0.38P AD=0.38P
+ PS=2.38U PD=2.38U
xM$198 VDD \$261 \$259 VDD sg13_lv_pmos L=0.13U W=2U AS=0.38P AD=0.68P PS=2.38U
+ PD=4.68U
xM$199 \$348 \$287 VDD VDD sg13_lv_pmos L=0.13U W=2U AS=0.68P AD=0.38P PS=4.68U
+ PD=2.38U
xM$200 \$321 \$319 \$348 VDD sg13_lv_pmos L=0.13U W=2U AS=0.38P AD=0.38P
+ PS=2.38U PD=2.38U
xM$201 \$346 \$286 \$321 VDD sg13_lv_pmos L=0.13U W=2U AS=0.38P AD=0.38P
+ PS=2.38U PD=2.38U
xM$202 VDD \$318 \$346 VDD sg13_lv_pmos L=0.13U W=2U AS=0.38P AD=0.68P PS=2.38U
+ PD=4.68U
xM$203 \$263 \$258 VDD VDD sg13_lv_pmos L=0.13U W=2U AS=0.68P AD=0.68P PS=4.68U
+ PD=4.68U
xM$204 \$322 \$321 VDD VDD sg13_lv_pmos L=0.13U W=2U AS=0.68P AD=0.68P PS=4.68U
+ PD=4.68U
xM$205 \$300 \$322 VDD VDD sg13_lv_pmos L=0.13U W=2U AS=0.68P AD=0.38P PS=4.68U
+ PD=2.38U
xM$206 VDD \$322 \$300 VDD sg13_lv_pmos L=0.13U W=2U AS=0.38P AD=0.38P PS=2.38U
+ PD=2.38U
xM$207 \$300 \$322 VDD VDD sg13_lv_pmos L=0.13U W=2U AS=0.38P AD=0.68P PS=2.38U
+ PD=4.68U
xM$208 \$260 \$263 VDD VDD sg13_lv_pmos L=0.13U W=2U AS=0.68P AD=0.38P PS=4.68U
+ PD=2.38U
xM$209 VDD \$263 \$260 VDD sg13_lv_pmos L=0.13U W=2U AS=0.38P AD=0.38P PS=2.38U
+ PD=2.38U
xM$210 \$260 \$263 VDD VDD sg13_lv_pmos L=0.13U W=2U AS=0.38P AD=0.68P PS=2.38U
+ PD=4.68U
xR$211 VSS VSS sub! rppd w=0.5 l=0.5 ps=0 b=0 m=1
xR$212 VSS VSS sub! rppd w=0.5 l=0.5 ps=0 b=0 m=1
xR$213 VSS VSS sub! rppd w=0.5 l=0.5 ps=0 b=0 m=1
xR$214 VSS VSS sub! rppd w=0.5 l=0.5 ps=0 b=0 m=1
xR$215 \$52 MEM sub! rppd w=0.5 l=0.5 ps=0 b=0 m=1
xR$216 VSS VSS sub! rppd w=0.5 l=0.5 ps=0 b=0 m=1
xR$217 VSS VSS sub! rppd w=0.5 l=0.5 ps=0 b=0 m=1
xR$218 \$52 MEM sub! rppd w=0.5 l=0.5 ps=0 b=0 m=1
xR$219 VSS VSS sub! rppd w=0.5 l=0.5 ps=0 b=0 m=1
xR$220 VSS VSS sub! rppd w=0.5 l=0.5 ps=0 b=0 m=1
xR$221 VSS VSS sub! rppd w=0.5 l=0.5 ps=0 b=0 m=1
xR$222 VSS VSS sub! rppd w=0.5 l=0.5 ps=0 b=0 m=1
xR$223 VSS VSS sub! rppd w=0.5 l=0.5 ps=0 b=0 m=1
xR$224 VSS VSS sub! rppd w=0.5 l=0.5 ps=0 b=0 m=1
xR$225 VSS VSS sub! rppd w=0.5 l=0.5 ps=0 b=0 m=1
xR$226 VSS VSS sub! rppd w=0.5 l=0.5 ps=0 b=0 m=1
xR$227 \$137 MEM sub! rppd w=0.5 l=0.5 ps=0 b=0 m=1
xR$228 VSS VSS sub! rppd w=0.5 l=0.5 ps=0 b=0 m=1
xR$229 VSS VSS sub! rppd w=0.5 l=0.5 ps=0 b=0 m=1
xR$230 \$137 MEM sub! rppd w=0.5 l=0.5 ps=0 b=0 m=1
xR$231 VSS VSS sub! rppd w=0.5 l=0.5 ps=0 b=0 m=1
xR$232 VSS VSS sub! rppd w=0.5 l=0.5 ps=0 b=0 m=1
xR$233 VSS VSS sub! rppd w=0.5 l=0.5 ps=0 b=0 m=1
xR$234 VSS VSS sub! rppd w=0.5 l=0.5 ps=0 b=0 m=1
xR$235 VSS VSS sub! rppd w=0.5 l=0.5 ps=0 b=0 m=1
xR$236 VSS VSS sub! rppd w=0.5 l=0.5 ps=0 b=0 m=1
xR$237 VSS VSS sub! rppd w=0.5 l=0.5 ps=0 b=0 m=1
xR$238 VSS VSS sub! rppd w=0.5 l=0.5 ps=0 b=0 m=1
xR$239 \$202 MEM sub! rppd w=0.5 l=0.5 ps=0 b=0 m=1
xR$240 VSS VSS sub! rppd w=0.5 l=0.5 ps=0 b=0 m=1
xR$241 VSS VSS sub! rppd w=0.5 l=0.5 ps=0 b=0 m=1
xR$242 \$202 MEM sub! rppd w=0.5 l=0.5 ps=0 b=0 m=1
xR$243 VSS VSS sub! rppd w=0.5 l=0.5 ps=0 b=0 m=1
xR$244 VSS VSS sub! rppd w=0.5 l=0.5 ps=0 b=0 m=1
xR$245 VSS VSS sub! rppd w=0.5 l=0.5 ps=0 b=0 m=1
xR$246 VSS VSS sub! rppd w=0.5 l=0.5 ps=0 b=0 m=1
xR$247 VSS VSS sub! rppd w=0.5 l=0.5 ps=0 b=0 m=1
xR$248 VSS VSS sub! rppd w=0.5 l=0.5 ps=0 b=0 m=1
xR$249 VSS VSS sub! rppd w=0.5 l=0.5 ps=0 b=0 m=1
xR$250 VSS VSS sub! rppd w=0.5 l=0.5 ps=0 b=0 m=1
xR$251 \$260 MEM sub! rppd w=0.5 l=0.5 ps=0 b=0 m=1
xR$252 VSS VSS sub! rppd w=0.5 l=0.5 ps=0 b=0 m=1
xR$253 VSS VSS sub! rppd w=0.5 l=0.5 ps=0 b=0 m=1
xR$254 \$260 MEM sub! rppd w=0.5 l=0.5 ps=0 b=0 m=1
xR$255 VSS VSS sub! rppd w=0.5 l=0.5 ps=0 b=0 m=1
xR$256 VSS VSS sub! rppd w=0.5 l=0.5 ps=0 b=0 m=1
xR$257 VSS VSS sub! rppd w=0.5 l=0.5 ps=0 b=0 m=1
xR$258 VSS VSS sub! rppd w=0.5 l=0.5 ps=0 b=0 m=1
xR$259 VSS VSS sub! rppd w=0.5 l=0.5 ps=0 b=0 m=1
xR$260 VSS VSS sub! rppd w=0.5 l=0.5 ps=0 b=0 m=1
xR$261 VSS VSS sub! rppd w=0.5 l=0.5 ps=0 b=0 m=1
xR$262 VSS VSS sub! rppd w=0.5 l=0.5 ps=0 b=0 m=1
xR$263 \$300 MEM sub! rppd w=0.5 l=0.5 ps=0 b=0 m=1
xR$264 VSS VSS sub! rppd w=0.5 l=0.5 ps=0 b=0 m=1
xR$265 VSS VSS sub! rppd w=0.5 l=0.5 ps=0 b=0 m=1
xR$266 \$300 MEM sub! rppd w=0.5 l=0.5 ps=0 b=0 m=1
xR$267 VSS VSS sub! rppd w=0.5 l=0.5 ps=0 b=0 m=1
xR$268 VSS VSS sub! rppd w=0.5 l=0.5 ps=0 b=0 m=1
xR$269 VSS VSS sub! rppd w=0.5 l=0.5 ps=0 b=0 m=1
xR$270 VSS VSS sub! rppd w=0.5 l=0.5 ps=0 b=0 m=1
xR$271 VDD VDD sub! rhigh w=0.5 l=4 ps=0 b=0 m=1
xR$272 VDD VDD sub! rhigh w=0.5 l=4 ps=0 b=0 m=1
xR$273 VDD VDD sub! rhigh w=0.5 l=4 ps=0 b=0 m=1
xR$274 VDD VDD sub! rhigh w=0.5 l=4 ps=0 b=0 m=1
xR$275 \$375 \$376 sub! rhigh w=0.5 l=4 ps=0 b=0 m=1
xR$276 \$377 \$375 sub! rhigh w=0.5 l=4 ps=0 b=0 m=1
xR$277 \$378 \$379 sub! rhigh w=0.5 l=4 ps=0 b=0 m=1
xR$278 \$380 \$378 sub! rhigh w=0.5 l=4 ps=0 b=0 m=1
xR$279 Vx \$376 sub! rhigh w=0.5 l=4 ps=0 b=0 m=1
xR$280 \$377 \$381 sub! rhigh w=0.5 l=4 ps=0 b=0 m=1
xR$281 \$381 \$379 sub! rhigh w=0.5 l=4 ps=0 b=0 m=1
xR$282 \$380 MEM sub! rhigh w=0.5 l=4 ps=0 b=0 m=1
xR$283 VDD VDD sub! rhigh w=0.5 l=4 ps=0 b=0 m=1
xR$284 VDD VDD sub! rhigh w=0.5 l=4 ps=0 b=0 m=1
xR$285 VDD VDD sub! rhigh w=0.5 l=4 ps=0 b=0 m=1
xR$286 VDD VDD sub! rhigh w=0.5 l=4 ps=0 b=0 m=1
Cext_1 \$10 \$11 169.877a
Cext_2 \$10 \$15 497.914a
Cext_3 \$10 \$41 0.0747556a
Cext_4 \$10 \$44 9.77118a
Cext_5 \$10 \$50 0.166316a
Cext_6 \$10 \$7 5.01123a
Cext_7 \$10 \$76 2.36416a
Cext_8 \$10 \$77 1.42153a
Cext_9 \$10 \$8 23.1623a
Cext_10 \$10 \$9 611.587a
Cext_11 \$10 RST 59.5139a
Cext_12 \$10 SPIKE 0.123586a
Cext_13 \$10 VDD 251.656a
Cext_14 \$10 VSS 85.8831a
Cext_15 \$10 sub! 371.953a
Cext_16 \$100 \$104 0.146273a
Cext_17 \$100 \$105 41.1301a
Cext_18 \$100 \$130 966.114a
Cext_19 \$100 \$131 207.365a
Cext_20 \$100 \$132 211.503a
Cext_21 \$100 \$133 267.592a
Cext_22 \$100 \$134 19.3541a
Cext_23 \$100 \$135 13.8067a
Cext_24 \$100 \$138 758.967a
Cext_25 \$100 \$139 0.135089a
Cext_26 \$100 \$164 9.30732a
Cext_27 \$100 \$165 265.902a
Cext_28 \$100 \$171 98.0717a
Cext_29 \$100 \$172 9.4977a
Cext_30 \$100 \$196 10.1452a
Cext_31 \$100 \$199 0.498248a
Cext_32 \$100 \$3 1.08403f
Cext_33 \$100 \$41 0.405347a
Cext_34 \$100 \$46 632.576a
Cext_35 \$100 \$47 21.937a
Cext_36 \$100 \$48 0.197475a
Cext_37 \$100 \$50 0.309799a
Cext_38 \$100 \$76 29.2121a
Cext_39 \$100 \$77 0.497612a
Cext_40 \$100 RST 0.855244a
Cext_41 \$100 SPIKE 6.77769a
Cext_42 \$100 VDD 563.33a
Cext_43 \$100 Vref 244.301a
Cext_44 \$100 VSS 268.741a
Cext_45 \$100 sub! 1.35228f
Cext_46 \$100 Vx 4.79911a
Cext_47 \$104 \$130 46.1099a
Cext_48 \$104 \$138 0.6349a
Cext_49 \$104 \$164 0.518582a
Cext_50 \$104 \$196 21.3883a
Cext_51 \$104 \$76 211.987a
Cext_52 \$104 VDD 236.006a
Cext_53 \$104 sub! 29.68a
Cext_54 \$105 \$130 0.391907a
Cext_55 \$105 \$138 22.3293a
Cext_56 \$105 \$165 0.518582a
Cext_57 \$105 \$46 211.829a
Cext_58 \$105 \$76 11.9453a
Cext_59 \$105 VDD 237.778a
Cext_60 \$105 sub! 29.5864a
Cext_61 \$106 \$130 0.124398a
Cext_62 \$106 \$133 0.233118a
Cext_63 \$106 \$46 20.4947a
Cext_64 \$106 \$49 0.185029a
Cext_65 \$106 \$50 199.584a
Cext_66 \$106 \$76 2.58383a
Cext_67 \$106 \$77 56.0763a
Cext_68 \$106 VDD 216.886a
Cext_69 \$106 sub! 27.9851a
Cext_70 \$107 \$133 0.184706a
Cext_71 \$107 \$135 0.482027a
Cext_72 \$107 \$46 0.597278a
Cext_73 \$107 \$48 19.659a
Cext_74 \$107 \$50 210.077a
Cext_75 \$107 \$51 0.185029a
Cext_76 \$107 \$76 29.198a
Cext_77 \$107 \$77 3.56119a
Cext_78 \$107 VDD 252.053a
Cext_79 \$107 sub! 29.9313a
Cext_80 \$11 \$12 225.704a
Cext_81 \$11 \$15 251.602a
Cext_82 \$11 \$50 7.43145a
Cext_83 \$11 \$78 2.16766a
Cext_84 \$11 \$9 4.86874a
Cext_85 \$11 RST 106.65a
Cext_86 \$11 SPIKE 0.274934a
Cext_87 \$11 VDD 329.15a
Cext_88 \$11 VSS 202.436a
Cext_89 \$11 sub! 809.785a
Cext_90 \$12 \$13 225.489a
Cext_91 \$12 \$15 204.648a
Cext_92 \$12 \$52 1.6466a
Cext_93 \$12 \$78 8.41194a
Cext_94 \$12 \$9 0.666148a
Cext_95 \$12 RST 105.45a
Cext_96 \$12 SPIKE 0.159809a
Cext_97 \$12 VDD 332.925a
Cext_98 \$12 VSS 205.104a
Cext_99 \$12 sub! 808.074a
Cext_100 \$13 \$14 227.399a
Cext_101 \$13 \$15 198.731a
Cext_102 \$13 \$52 3.23399a
Cext_103 \$13 \$9 0.318527a
Cext_104 \$13 RST 106.333a
Cext_105 \$13 VDD 336.002a
Cext_106 \$13 VSS 209.838a
Cext_107 \$13 sub! 810.951a
Cext_108 \$130 \$131 13.0381a
Cext_109 \$130 \$132 692.9a
Cext_110 \$130 \$133 840.967a
Cext_111 \$130 \$134 1.61039a
Cext_112 \$130 \$135 396.474a
Cext_113 \$130 \$136 28.5519a
Cext_114 \$130 \$138 145.352a
Cext_115 \$130 \$139 218.223a
Cext_116 \$130 \$140 9.09611a
Cext_117 \$130 \$164 253.17a
Cext_118 \$130 \$165 6.81589a
Cext_119 \$130 \$166 98.0717a
Cext_120 \$130 \$172 21.2936a
Cext_121 \$130 \$196 539.849a
Cext_122 \$130 \$198 1.19087a
Cext_123 \$130 \$199 0.588839a
Cext_124 \$130 \$3 101.823a
Cext_125 \$130 \$4 1.02968a
Cext_126 \$130 \$45 20.7687a
Cext_127 \$130 \$46 359.18a
Cext_128 \$130 \$48 0.699405a
Cext_129 \$130 \$50 0.865932a
Cext_130 \$130 \$76 619.807a
Cext_131 \$130 \$77 0.379159a
Cext_132 \$130 SPIKE 0.465718a
Cext_133 \$130 VDD 588.037a
Cext_134 \$130 Vref 54.2387a
Cext_135 \$130 VSS 272.847a
Cext_136 \$130 sub! 1.41646f
Cext_137 \$130 Vx 208.374a
Cext_138 \$131 \$138 24.1635a
Cext_139 \$131 \$165 30.2471a
Cext_140 \$131 \$46 0.712711a
Cext_141 \$131 \$76 0.915371a
Cext_142 \$131 VDD 238.366a
Cext_143 \$131 sub! 30.4539a
Cext_144 \$132 \$133 862.212a
Cext_145 \$132 \$135 235.204a
Cext_146 \$132 \$136 19.6231a
Cext_147 \$132 \$137 1.38144a
Cext_148 \$132 \$138 1.1535a
Cext_149 \$132 \$140 18.2166a
Cext_150 \$132 \$164 0.862943a
Cext_151 \$132 \$165 1.03186a
Cext_152 \$132 \$167 18.6588a
Cext_153 \$132 \$171 0.167938a
Cext_154 \$132 \$172 7.88112a
Cext_155 \$132 \$198 35.4785a
Cext_156 \$132 \$200 0.254046a
Cext_157 \$132 \$46 20.3058a
Cext_158 \$132 \$48 4.86902a
Cext_159 \$132 \$50 0.865932a
Cext_160 \$132 \$76 0.915371a
Cext_161 \$132 VDD 476.063a
Cext_162 \$132 Vref 8.1416a
Cext_163 \$132 VSS 310.813a
Cext_164 \$132 sub! 505.195a
Cext_165 \$133 \$134 57.2982a
Cext_166 \$133 \$135 358.871a
Cext_167 \$133 \$136 3.56119a
Cext_168 \$133 \$137 1.86333a
Cext_169 \$133 \$138 0.52211a
Cext_170 \$133 \$140 4.39311a
Cext_171 \$133 \$164 0.588839a
Cext_172 \$133 \$165 1.6378a
Cext_173 \$133 \$167 49.7752a
Cext_174 \$133 \$172 12.6372a
Cext_175 \$133 \$177 0.401837a
Cext_176 \$133 \$178 0.443406a
Cext_177 \$133 \$199 74.5299a
Cext_178 \$133 \$200 0.110852a
Cext_179 \$133 \$46 19.7997a
Cext_180 \$133 \$76 0.379159a
Cext_181 \$133 \$77 8.85402a
Cext_182 \$133 VDD 380.424a
Cext_183 \$133 Vref 0.289989a
Cext_184 \$133 VSS 262.635a
Cext_185 \$133 sub! 429.165a
Cext_186 \$133 Vx 0.249803a
Cext_187 \$134 \$135 200.016a
Cext_188 \$134 \$172 0.185029a
Cext_189 \$134 \$46 1.32314a
Cext_190 \$134 \$76 0.124398a
Cext_191 \$134 \$77 0.233118a
Cext_192 \$134 VDD 218.084a
Cext_193 \$134 sub! 28.5986a
Cext_194 \$135 \$136 210.642a
Cext_195 \$135 \$137 10.6747a
Cext_196 \$135 \$140 201.584a
Cext_197 \$135 \$165 0.341988a
Cext_198 \$135 \$167 98.0717a
Cext_199 \$135 \$172 98.0717a
Cext_200 \$135 \$178 10.7813a
Cext_201 \$135 \$199 0.443406a
Cext_202 \$135 \$46 1.99168a
Cext_203 \$135 \$48 0.727383a
Cext_204 \$135 \$50 20.202a
Cext_205 \$135 \$76 0.865932a
Cext_206 \$135 VDD 90.4777a
Cext_207 \$135 VSS 82.0775a
Cext_208 \$135 sub! 563.45a
Cext_209 \$136 \$167 0.185029a
Cext_210 \$136 \$46 0.841819a
Cext_211 \$136 \$50 0.482027a
Cext_212 \$136 \$77 0.184706a
Cext_213 \$136 VDD 252.721a
Cext_214 \$136 sub! 30.3212a
Cext_215 \$137 \$138 0.221681a
Cext_216 \$137 \$140 464.216a
Cext_217 \$137 \$201 1.37487a
Cext_218 \$137 \$202 28.7587a
Cext_219 \$137 \$46 0.338941a
Cext_220 \$137 \$52 36.2613a
Cext_221 \$137 \$78 1.70191a
Cext_222 \$137 MEM 134.851a
Cext_223 \$137 VDD 650.51a
Cext_224 \$137 VSS 803.393a
Cext_225 \$137 sub! 576.099a
Cext_226 \$138 \$139 1.96705a
Cext_227 \$138 \$164 30.9917a
Cext_228 \$138 \$165 534.263a
Cext_229 \$138 \$171 0.7041a
Cext_230 \$138 \$196 45.1129a
Cext_231 \$138 \$197 1.82883a
Cext_232 \$138 \$198 0.867582a
Cext_233 \$138 \$199 0.168207a
Cext_234 \$138 \$223 30.6623a
Cext_235 \$138 \$228 22.1768a
Cext_236 \$138 \$255 742.72a
Cext_237 \$138 \$256 22.5483a
Cext_238 \$138 \$261 1.14995a
Cext_239 \$138 \$262 0.168207a
Cext_240 \$138 \$286 12.378a
Cext_241 \$138 \$287 578.386a
Cext_242 \$138 \$292 0.932704a
Cext_243 \$138 \$298 1.82883a
Cext_244 \$138 \$3 90.1463a
Cext_245 \$138 \$318 1.00013a
Cext_246 \$138 \$319 0.168207a
Cext_247 \$138 \$347 19.6365a
Cext_248 \$138 \$375 0.114033a
Cext_249 \$138 \$45 0.13685a
Cext_250 \$138 \$46 529.692a
Cext_251 \$138 \$48 0.119911a
Cext_252 \$138 \$7 0.460633a
Cext_253 \$138 \$76 117.917a
Cext_254 \$138 VDD 741.941a
Cext_255 \$138 Vref 5.12795f
Cext_256 \$138 VSS 236.099a
Cext_257 \$138 sub! 1.88493f
Cext_258 \$138 Vx 20.7935a
Cext_259 \$139 \$164 31.8476a
Cext_260 \$139 \$196 22.7794a
Cext_261 \$139 \$76 0.915371a
Cext_262 \$139 VDD 236.496a
Cext_263 \$139 sub! 30.234a
Cext_264 \$14 \$15 419.424a
Cext_265 \$14 \$16 0.811338a
Cext_266 \$14 \$52 3.03543a
Cext_267 \$14 \$9 0.179409a
Cext_268 \$14 MEM 0.14806a
Cext_269 \$14 RST 106.665a
Cext_270 \$14 VDD 361.829a
Cext_271 \$14 VSS 220.275a
Cext_272 \$14 sub! 816.497a
Cext_273 \$140 \$201 31.403a
Cext_274 \$140 \$202 1.37487a
Cext_275 \$140 \$46 1.40382a
Cext_276 \$140 \$52 1.70191a
Cext_277 \$140 \$78 18.4185a
Cext_278 \$140 MEM 0.877361a
Cext_279 \$140 VDD 565.822a
Cext_280 \$140 Vref 0.399745a
Cext_281 \$140 VSS 356.456a
Cext_282 \$140 sub! 1.13454f
Cext_283 \$15 \$16 497.246a
Cext_284 \$15 \$2 19.7307a
Cext_285 \$15 \$3 4.28649a
Cext_286 \$15 \$4 0.520426a
Cext_287 \$15 \$41 548.774a
Cext_288 \$15 \$44 52.3485a
Cext_289 \$15 \$46 4.59306a
Cext_290 \$15 \$48 22.4496a
Cext_291 \$15 \$5 38.5858a
Cext_292 \$15 \$50 9.96803a
Cext_293 \$15 \$51 0.107373a
Cext_294 \$15 \$52 35.8571a
Cext_295 \$15 \$7 322.387a
Cext_296 \$15 \$76 0.910804a
Cext_297 \$15 \$77 41.0229a
Cext_298 \$15 \$78 23.4769a
Cext_299 \$15 \$8 48.2118a
Cext_300 \$15 \$9 163.24a
Cext_301 \$15 MEM 73.9805a
Cext_302 \$15 RST 458.86a
Cext_303 \$15 SPIKE 517.321a
Cext_304 \$15 VDD 633.509a
Cext_305 \$15 VSS 522.878a
Cext_306 \$15 sub! 1.64236f
Cext_307 \$16 MEM 548.491a
Cext_308 \$16 RST 1.41118a
Cext_309 \$16 VDD 519.152a
Cext_310 \$16 VSS 363.249a
Cext_311 \$16 sub! 770.94a
Cext_312 \$164 \$165 936.178a
Cext_313 \$164 \$166 33.0911a
Cext_314 \$164 \$176 102.304a
Cext_315 \$164 \$177 21.2936a
Cext_316 \$164 \$178 396.242a
Cext_317 \$164 \$196 579.005a
Cext_318 \$164 \$198 666.227a
Cext_319 \$164 \$199 843.516a
Cext_320 \$164 \$201 9.50349a
Cext_321 \$164 \$202 0.135648a
Cext_322 \$164 \$223 478.745a
Cext_323 \$164 \$227 211.684a
Cext_324 \$164 \$228 12.4919a
Cext_325 \$164 \$229 29.0382a
Cext_326 \$164 \$230 2.25158a
Cext_327 \$164 \$254 0.666059a
Cext_328 \$164 \$255 31.4666a
Cext_329 \$164 \$256 0.666059a
Cext_330 \$164 \$257 0.124398a
Cext_331 \$164 \$258 0.865932a
Cext_332 \$164 \$261 0.661425a
Cext_333 \$164 \$262 0.379159a
Cext_334 \$164 \$286 2.40931a
Cext_335 \$164 \$287 0.982648a
Cext_336 \$164 \$3 147.266a
Cext_337 \$164 \$46 252.342a
Cext_338 \$164 \$76 158.727a
Cext_339 \$164 VDD 579.932a
Cext_340 \$164 Vref 57.169a
Cext_341 \$164 VSS 283.7a
Cext_342 \$164 sub! 1.40265f
Cext_343 \$164 Vx 230.893a
Cext_344 \$165 \$171 33.0911a
Cext_345 \$165 \$177 9.4977a
Cext_346 \$165 \$178 13.8104a
Cext_347 \$165 \$196 6.75853a
Cext_348 \$165 \$197 102.284a
Cext_349 \$165 \$198 220.158a
Cext_350 \$165 \$199 269.069a
Cext_351 \$165 \$223 15.5149a
Cext_352 \$165 \$228 209.568a
Cext_353 \$165 \$230 19.5394a
Cext_354 \$165 \$255 293.471a
Cext_355 \$165 \$262 0.497612a
Cext_356 \$165 \$3 748.172a
Cext_357 \$165 \$46 44.0297a
Cext_358 \$165 \$76 1.15203a
Cext_359 \$165 VDD 567.094a
Cext_360 \$165 Vref 248.071a
Cext_361 \$165 VSS 276.35a
Cext_362 \$165 sub! 1.37191f
Cext_363 \$165 Vx 6.33782a
Cext_364 \$166 \$196 0.7041a
Cext_365 \$166 \$223 0.63626a
Cext_366 \$166 Vref 0.408958a
Cext_367 \$166 VSS 129.572a
Cext_368 \$166 sub! 16.1208a
Cext_369 \$166 Vx 10.097a
Cext_370 \$167 \$198 0.254046a
Cext_371 \$167 \$199 0.110852a
Cext_372 \$167 \$46 0.134203a
Cext_373 \$167 VSS 136.977a
Cext_374 \$167 sub! 14.2823a
Cext_375 \$171 \$255 0.63626a
Cext_376 \$171 Vref 10.2115a
Cext_377 \$171 VSS 130.507a
Cext_378 \$171 sub! 16.1208a
Cext_379 \$172 \$199 0.401837a
Cext_380 \$172 \$46 0.393105a
Cext_381 \$172 VSS 120.012a
Cext_382 \$172 sub! 15.4998a
Cext_383 \$176 \$196 1.82883a
Cext_384 \$176 \$223 22.0172a
Cext_385 \$176 \$3 0.143514a
Cext_386 \$176 Vref 0.705456a
Cext_387 \$176 VSS 129.572a
Cext_388 \$176 sub! 16.1208a
Cext_389 \$176 Vx 10.9221a
Cext_390 \$177 \$178 98.0717a
Cext_391 \$177 \$198 7.88112a
Cext_392 \$177 \$199 12.6372a
Cext_393 \$177 \$230 0.185029a
Cext_394 \$177 \$46 0.393105a
Cext_395 \$177 VSS 120.012a
Cext_396 \$177 sub! 15.4998a
Cext_397 \$178 \$198 234.571a
Cext_398 \$178 \$199 359.164a
Cext_399 \$178 \$200 98.0717a
Cext_400 \$178 \$201 201.739a
Cext_401 \$178 \$202 10.6747a
Cext_402 \$178 \$223 0.865932a
Cext_403 \$178 \$229 209.993a
Cext_404 \$178 \$230 198.848a
Cext_405 \$178 \$255 0.235857a
Cext_406 \$178 \$258 20.202a
Cext_407 \$178 \$259 0.482027a
Cext_408 \$178 \$261 0.865932a
Cext_409 \$178 \$46 1.47105a
Cext_410 \$178 VDD 90.4793a
Cext_411 \$178 VSS 82.0775a
Cext_412 \$178 sub! 562.905a
Cext_413 \$196 \$223 677.94a
Cext_414 \$196 \$227 23.943a
Cext_415 \$196 \$254 22.9598a
Cext_416 \$196 \$255 9.326a
Cext_417 \$196 \$286 460.784a
Cext_418 \$196 \$287 30.8313a
Cext_419 \$196 \$291 0.932704a
Cext_420 \$196 \$3 158.637a
Cext_421 \$196 \$317 1.82883a
Cext_422 \$196 \$345 19.6365a
Cext_423 \$196 \$375 0.114033a
Cext_424 \$196 \$46 1.50101a
Cext_425 \$196 \$76 240.631a
Cext_426 \$196 VDD 876.789a
Cext_427 \$196 Vref 21.6157a
Cext_428 \$196 VSS 209.564a
Cext_429 \$196 sub! 1.84809f
Cext_430 \$196 Vx 4.12464f
Cext_431 \$197 \$198 0.100763a
Cext_432 \$197 \$255 22.0172a
Cext_433 \$197 \$3 0.381393a
Cext_434 \$197 Vref 10.508a
Cext_435 \$197 VSS 130.507a
Cext_436 \$197 sub! 16.1208a
Cext_437 \$198 \$199 862.196a
Cext_438 \$198 \$200 18.6588a
Cext_439 \$198 \$201 18.2725a
Cext_440 \$198 \$202 1.38144a
Cext_441 \$198 \$223 0.92314a
Cext_442 \$198 \$229 19.5335a
Cext_443 \$198 \$255 0.625346a
Cext_444 \$198 \$258 0.865932a
Cext_445 \$198 \$261 4.86902a
Cext_446 \$198 \$3 1.1356a
Cext_447 \$198 \$46 20.5221a
Cext_448 \$198 VDD 473.295a
Cext_449 \$198 Vref 8.00302a
Cext_450 \$198 VSS 310.708a
Cext_451 \$198 sub! 504.558a
Cext_452 \$198 Vx 0.125713a
Cext_453 \$199 \$200 49.8511a
Cext_454 \$199 \$201 4.39311a
Cext_455 \$199 \$202 1.86333a
Cext_456 \$199 \$223 0.379159a
Cext_457 \$199 \$229 3.56119a
Cext_458 \$199 \$230 57.2085a
Cext_459 \$199 \$255 0.497612a
Cext_460 \$199 \$257 0.233118a
Cext_461 \$199 \$259 0.184706a
Cext_462 \$199 \$262 8.9556a
Cext_463 \$199 \$3 0.424964a
Cext_464 \$199 \$46 18.4341a
Cext_465 \$199 VDD 378.428a
Cext_466 \$199 Vref 0.34858a
Cext_467 \$199 VSS 262.894a
Cext_468 \$199 sub! 430.969a
Cext_469 \$2 \$41 196.143a
Cext_470 \$2 \$46 0.118209a
Cext_471 \$2 RST 65.0541a
Cext_472 \$2 VDD 215.259a
Cext_473 \$2 sub! 29.2171a
Cext_474 \$200 \$229 0.185029a
Cext_475 \$200 \$46 0.134203a
Cext_476 \$200 VSS 136.977a
Cext_477 \$200 sub! 14.2823a
Cext_478 \$201 \$202 464.448a
Cext_479 \$201 \$260 1.70191a
Cext_480 \$201 \$263 18.4185a
Cext_481 \$201 \$46 0.903861a
Cext_482 \$201 MEM 0.877361a
Cext_483 \$201 VDD 564.796a
Cext_484 \$201 VSS 356.449a
Cext_485 \$201 sub! 1.13382f
Cext_486 \$202 \$260 36.2613a
Cext_487 \$202 \$263 1.70191a
Cext_488 \$202 \$46 0.22596a
Cext_489 \$202 MEM 134.883a
Cext_490 \$202 VDD 650.51a
Cext_491 \$202 VSS 803.505a
Cext_492 \$202 sub! 575.99a
Cext_493 \$223 \$227 42.8053a
Cext_494 \$223 \$228 0.568736a
Cext_495 \$223 \$230 0.124398a
Cext_496 \$223 \$254 215.409a
Cext_497 \$223 \$255 671.476a
Cext_498 \$223 \$256 14.0621a
Cext_499 \$223 \$257 2.01947a
Cext_500 \$223 \$258 397.112a
Cext_501 \$223 \$259 29.0752a
Cext_502 \$223 \$260 0.102136a
Cext_503 \$223 \$261 703.217a
Cext_504 \$223 \$262 831.371a
Cext_505 \$223 \$263 9.40169a
Cext_506 \$223 \$286 197.121a
Cext_507 \$223 \$287 7.12467a
Cext_508 \$223 \$291 98.0717a
Cext_509 \$223 \$293 19.9641a
Cext_510 \$223 \$3 90.0461a
Cext_511 \$223 \$318 1.79487a
Cext_512 \$223 \$319 0.588839a
Cext_513 \$223 \$46 396.791a
Cext_514 \$223 \$76 775.636a
Cext_515 \$223 VDD 677.332a
Cext_516 \$223 Vref 30.9415a
Cext_517 \$223 VSS 288.828a
Cext_518 \$223 sub! 1.46943f
Cext_519 \$223 Vx 221.625a
Cext_520 \$227 \$286 0.627025a
Cext_521 \$227 VDD 235.182a
Cext_522 \$227 sub! 30.1198a
Cext_523 \$227 Vx 0.979531a
Cext_524 \$228 \$255 35.7234a
Cext_525 \$228 \$287 0.627025a
Cext_526 \$228 VDD 236.601a
Cext_527 \$228 Vref 0.296081a
Cext_528 \$228 sub! 30.1683a
Cext_529 \$229 \$258 0.482027a
Cext_530 \$229 \$262 0.184706a
Cext_531 \$229 \$46 0.561213a
Cext_532 \$229 VDD 252.053a
Cext_533 \$229 sub! 30.0987a
Cext_534 \$230 \$262 0.233118a
Cext_535 \$230 \$46 0.982764a
Cext_536 \$230 VDD 216.858a
Cext_537 \$230 sub! 28.8423a
Cext_538 \$254 \$255 0.160617a
Cext_539 \$254 \$286 32.3584a
Cext_540 \$254 VDD 236.496a
Cext_541 \$254 sub! 30.1972a
Cext_542 \$254 Vx 0.855605a
Cext_543 \$255 \$256 208.701a
Cext_544 \$255 \$257 19.4797a
Cext_545 \$255 \$258 13.8131a
Cext_546 \$255 \$261 211.777a
Cext_547 \$255 \$262 269.01a
Cext_548 \$255 \$286 9.23131a
Cext_549 \$255 \$287 250.261a
Cext_550 \$255 \$292 98.0717a
Cext_551 \$255 \$293 9.43492a
Cext_552 \$255 \$3 1.15288f
Cext_553 \$255 \$319 0.498248a
Cext_554 \$255 \$46 43.3827a
Cext_555 \$255 VDD 577.268a
Cext_556 \$255 Vref 209.098a
Cext_557 \$255 VSS 267.446a
Cext_558 \$255 sub! 1.3505f
Cext_559 \$255 Vx 5.85893a
Cext_560 \$256 \$287 30.3047a
Cext_561 \$256 VDD 238.366a
Cext_562 \$256 sub! 30.3255a
Cext_563 \$257 \$258 200.074a
Cext_564 \$257 \$262 57.3699a
Cext_565 \$257 \$293 0.185029a
Cext_566 \$257 \$46 1.07385a
Cext_567 \$257 VDD 218.084a
Cext_568 \$257 sub! 28.6926a
Cext_569 \$258 \$259 210.728a
Cext_570 \$258 \$260 10.6747a
Cext_571 \$258 \$261 238.475a
Cext_572 \$258 \$262 347.847a
Cext_573 \$258 \$263 200.929a
Cext_574 \$258 \$287 0.310351a
Cext_575 \$258 \$293 98.0717a
Cext_576 \$258 \$294 98.0717a
Cext_577 \$258 \$319 0.443406a
Cext_578 \$258 \$321 10.7813a
Cext_579 \$258 \$46 1.62319a
Cext_580 \$258 VDD 90.6107a
Cext_581 \$258 VSS 81.6877a
Cext_582 \$258 sub! 564.358a
Cext_583 \$259 \$261 19.6949a
Cext_584 \$259 \$262 3.56119a
Cext_585 \$259 \$294 0.185029a
Cext_586 \$259 \$46 0.683216a
Cext_587 \$259 VDD 252.721a
Cext_588 \$259 sub! 29.9643a
Cext_589 \$260 \$261 1.38144a
Cext_590 \$260 \$262 1.86333a
Cext_591 \$260 \$263 464.26a
Cext_592 \$260 \$300 28.7587a
Cext_593 \$260 \$322 1.37487a
Cext_594 \$260 \$46 0.22596a
Cext_595 \$260 MEM 134.851a
Cext_596 \$260 VDD 650.51a
Cext_597 \$260 VSS 803.386a
Cext_598 \$260 sub! 575.932a
Cext_599 \$261 \$262 823.613a
Cext_600 \$261 \$263 18.3987a
Cext_601 \$261 \$286 0.862943a
Cext_602 \$261 \$287 1.2505a
Cext_603 \$261 \$292 0.167938a
Cext_604 \$261 \$293 7.76043a
Cext_605 \$261 \$294 18.623a
Cext_606 \$261 \$299 0.254046a
Cext_607 \$261 \$318 35.5208a
Cext_608 \$261 \$46 19.8918a
Cext_609 \$261 VDD 476.363a
Cext_610 \$261 Vref 7.73395a
Cext_611 \$261 VSS 310.49a
Cext_612 \$261 sub! 505.983a
Cext_613 \$262 \$263 4.28985a
Cext_614 \$262 \$286 0.588839a
Cext_615 \$262 \$287 0.430305a
Cext_616 \$262 \$293 12.5225a
Cext_617 \$262 \$294 49.6304a
Cext_618 \$262 \$299 0.110852a
Cext_619 \$262 \$319 73.7465a
Cext_620 \$262 \$320 0.290985a
Cext_621 \$262 \$46 18.7182a
Cext_622 \$262 VDD 381.039a
Cext_623 \$262 Vref 0.34858a
Cext_624 \$262 VSS 262.052a
Cext_625 \$262 sub! 428.067a
Cext_626 \$262 Vx 0.499606a
Cext_627 \$263 \$300 1.37487a
Cext_628 \$263 \$322 31.403a
Cext_629 \$263 \$46 0.903861a
Cext_630 \$263 MEM 0.877361a
Cext_631 \$263 VDD 566.091a
Cext_632 \$263 VSS 356.314a
Cext_633 \$263 sub! 1.13333f
Cext_634 \$286 \$287 1.02271f
Cext_635 \$286 \$291 32.3103a
Cext_636 \$286 \$3 122.763a
Cext_637 \$286 \$317 104.553a
Cext_638 \$286 \$318 699.529a
Cext_639 \$286 \$319 796.923a
Cext_640 \$286 \$320 20.1255a
Cext_641 \$286 \$321 400.634a
Cext_642 \$286 \$322 9.10429a
Cext_643 \$286 \$345 213.041a
Cext_644 \$286 \$346 28.7245a
Cext_645 \$286 \$347 12.8839a
Cext_646 \$286 \$348 2.10349a
Cext_647 \$286 \$375 0.207298a
Cext_648 \$286 \$378 0.158528a
Cext_649 \$286 \$46 88.3057a
Cext_650 \$286 \$76 348.572a
Cext_651 \$286 VDD 699.463a
Cext_652 \$286 Vref 10.9844a
Cext_653 \$286 VSS 286.612a
Cext_654 \$286 sub! 1.4889f
Cext_655 \$286 Vx 230.14a
Cext_656 \$287 \$292 32.2447a
Cext_657 \$287 \$298 104.503a
Cext_658 \$287 \$3 814.97a
Cext_659 \$287 \$317 0.173497a
Cext_660 \$287 \$318 218.889a
Cext_661 \$287 \$319 269.15a
Cext_662 \$287 \$320 9.4977a
Cext_663 \$287 \$321 8.96215a
Cext_664 \$287 \$345 0.645969a
Cext_665 \$287 \$347 206.127a
Cext_666 \$287 \$348 19.5839a
Cext_667 \$287 \$375 0.115607a
Cext_668 \$287 \$46 274.624a
Cext_669 \$287 \$76 4.00911a
Cext_670 \$287 VDD 585.768a
Cext_671 \$287 Vref 223.789a
Cext_672 \$287 VSS 277.057a
Cext_673 \$287 sub! 1.38771f
Cext_674 \$287 Vx 2.46644a
Cext_675 \$291 \$76 0.277447a
Cext_676 \$291 VSS 129.572a
Cext_677 \$291 sub! 16.1208a
Cext_678 \$291 Vx 9.73979a
Cext_679 \$292 \$46 0.282818a
Cext_680 \$292 Vref 9.73979a
Cext_681 \$292 VSS 130.507a
Cext_682 \$292 sub! 16.0696a
Cext_683 \$293 \$319 0.401837a
Cext_684 \$293 \$46 0.393105a
Cext_685 \$293 VSS 119.304a
Cext_686 \$293 sub! 15.4486a
Cext_687 \$294 \$318 0.254046a
Cext_688 \$294 \$319 0.110852a
Cext_689 \$294 \$46 0.134203a
Cext_690 \$294 VSS 136.623a
Cext_691 \$294 sub! 14.2567a
Cext_692 \$298 \$318 0.125954a
Cext_693 \$298 \$46 19.7337a
Cext_694 \$298 Vref 11.0715a
Cext_695 \$298 VSS 130.507a
Cext_696 \$298 sub! 16.1208a
Cext_697 \$299 \$318 18.6588a
Cext_698 \$299 \$319 49.1662a
Cext_699 \$299 \$321 98.0717a
Cext_700 \$299 \$346 0.185029a
Cext_701 \$299 \$46 0.134203a
Cext_702 \$299 VSS 136.623a
Cext_703 \$299 sub! 14.0938a
Cext_704 \$3 \$317 0.217928a
Cext_705 \$3 \$319 0.106684a
Cext_706 \$3 \$321 0.23941a
Cext_707 \$3 \$376 0.169393a
Cext_708 \$3 \$4 461.505a
Cext_709 \$3 \$41 1.7835a
Cext_710 \$3 \$45 12.1284a
Cext_711 \$3 \$46 276.34a
Cext_712 \$3 \$47 1.81141a
Cext_713 \$3 \$48 1.34233a
Cext_714 \$3 \$5 3.46398a
Cext_715 \$3 \$50 0.831258a
Cext_716 \$3 \$7 0.243708a
Cext_717 \$3 \$76 4.48453f
Cext_718 \$3 \$77 8.69071a
Cext_719 \$3 RST 781.781a
Cext_720 \$3 SPIKE 267.446a
Cext_721 \$3 VDD 946.16a
Cext_722 \$3 Vref 195.556a
Cext_723 \$3 VSS 921.952a
Cext_724 \$3 sub! 3.17138f
Cext_725 \$3 Vx 5.97605f
Cext_726 \$300 \$318 1.38144a
Cext_727 \$300 \$319 1.86333a
Cext_728 \$300 \$321 10.6747a
Cext_729 \$300 \$322 462.548a
Cext_730 \$300 MEM 134.851a
Cext_731 \$300 VDD 708.281a
Cext_732 \$300 VSS 799.682a
Cext_733 \$300 sub! 558.649a
Cext_734 \$317 \$76 19.6569a
Cext_735 \$317 VSS 129.572a
Cext_736 \$317 sub! 15.9496a
Cext_737 \$317 Vx 11.1189a
Cext_738 \$318 \$319 794.591a
Cext_739 \$318 \$320 7.88112a
Cext_740 \$318 \$321 238.579a
Cext_741 \$318 \$322 18.3893a
Cext_742 \$318 \$346 19.6769a
Cext_743 \$318 \$46 15.9199a
Cext_744 \$318 VDD 479.405a
Cext_745 \$318 Vref 7.65962a
Cext_746 \$318 VSS 309.862a
Cext_747 \$318 sub! 508.324a
Cext_748 \$319 \$320 12.4422a
Cext_749 \$319 \$321 346.005a
Cext_750 \$319 \$322 4.24958a
Cext_751 \$319 \$346 3.47752a
Cext_752 \$319 \$348 56.3867a
Cext_753 \$319 \$375 0.0905873a
Cext_754 \$319 \$381 0.109273a
Cext_755 \$319 \$46 16.399a
Cext_756 \$319 VDD 389.806a
Cext_757 \$319 Vref 0.34858a
Cext_758 \$319 VSS 260.998a
Cext_759 \$319 sub! 427.609a
Cext_760 \$320 \$321 98.0717a
Cext_761 \$320 \$348 0.185029a
Cext_762 \$320 \$46 0.393105a
Cext_763 \$320 VSS 119.304a
Cext_764 \$320 sub! 15.294a
Cext_765 \$321 \$322 200.884a
Cext_766 \$321 \$346 210.852a
Cext_767 \$321 \$348 199.806a
Cext_768 \$321 \$46 0.691284a
Cext_769 \$321 VDD 119.67a
Cext_770 \$321 VSS 81.5662a
Cext_771 \$321 sub! 564.452a
Cext_772 \$322 MEM 0.877361a
Cext_773 \$322 VDD 584.783a
Cext_774 \$322 VSS 356.107a
Cext_775 \$322 sub! 1.13852f
Cext_776 \$345 \$76 30.0399a
Cext_777 \$345 VDD 237.6a
Cext_778 \$345 sub! 30.6679a
Cext_779 \$345 Vx 0.444845a
Cext_780 \$346 VDD 254.701a
Cext_781 \$346 sub! 30.5044a
Cext_782 \$347 \$46 29.132a
Cext_783 \$347 VDD 239.971a
Cext_784 \$347 sub! 30.6168a
Cext_785 \$347 Vx 0.186523a
Cext_786 \$348 VDD 220.257a
Cext_787 \$348 sub! 29.0605a
Cext_788 \$375 \$376 33.2931a
Cext_789 \$375 \$377 33.2659a
Cext_790 \$375 \$378 79.6363a
Cext_791 \$375 \$381 37.5904a
Cext_792 \$375 VDD 1.3934f
Cext_793 \$375 sub! 399.241a
Cext_794 \$375 Vx 61.4649a
Cext_795 \$376 \$377 143.934a
Cext_796 \$376 VDD 133.342a
Cext_797 \$376 sub! 174.215a
Cext_798 \$376 Vx 2.14536a
Cext_799 \$377 \$381 1.47372a
Cext_800 \$377 \$46 0.080619a
Cext_801 \$377 VDD 130.382a
Cext_802 \$377 sub! 174.075a
Cext_803 \$377 Vx 0.333208a
Cext_804 \$378 \$379 33.3003a
Cext_805 \$378 \$380 33.368a
Cext_806 \$378 \$381 37.5033a
Cext_807 \$378 MEM 68.0221a
Cext_808 \$378 VDD 1.3816f
Cext_809 \$378 VSS 1.02912a
Cext_810 \$378 sub! 401.414a
Cext_811 \$379 \$380 154.565a
Cext_812 \$379 \$381 1.47372a
Cext_813 \$379 MEM 0.417649a
Cext_814 \$379 VDD 124.636a
Cext_815 \$379 sub! 176.074a
Cext_816 \$380 MEM 2.2395a
Cext_817 \$380 VDD 128.233a
Cext_818 \$380 sub! 174.171a
Cext_819 \$381 VDD 97.419a
Cext_820 \$381 sub! 191.535a
Cext_821 \$4 \$41 7.07135a
Cext_822 \$4 \$5 200.992a
Cext_823 \$4 \$76 1.12141a
Cext_824 \$4 RST 91.686a
Cext_825 \$4 SPIKE 128.511a
Cext_826 \$4 VDD 520.39a
Cext_827 \$4 VSS 289.603a
Cext_828 \$4 sub! 1.12944f
Cext_829 \$4 Vx 0.786842a
Cext_830 \$41 \$46 0.99904a
Cext_831 \$41 \$5 186.172a
Cext_832 \$41 \$7 13.2154a
Cext_833 \$41 RST 294.999a
Cext_834 \$41 SPIKE 238.62a
Cext_835 \$41 VDD 63.4984a
Cext_836 \$41 VSS 250.244a
Cext_837 \$41 sub! 447.591a
Cext_838 \$41 Vx 1.17988a
Cext_839 \$44 \$77 1.19022a
Cext_840 \$44 \$9 97.383a
Cext_841 \$44 VSS 119.44a
Cext_842 \$44 sub! 15.3638a
Cext_843 \$45 \$76 98.0717a
Cext_844 \$45 SPIKE 0.26997a
Cext_845 \$45 VSS 129.572a
Cext_846 \$45 sub! 15.9282a
Cext_847 \$45 Vx 9.71291a
Cext_848 \$46 \$47 99.1866a
Cext_849 \$46 \$48 229.165a
Cext_850 \$46 \$49 9.4977a
Cext_851 \$46 \$50 15.057a
Cext_852 \$46 \$52 0.108068a
Cext_853 \$46 \$7 7.69379a
Cext_854 \$46 \$76 1.06672f
Cext_855 \$46 \$77 269.476a
Cext_856 \$46 \$78 0.975584a
Cext_857 \$46 \$9 1.96802a
Cext_858 \$46 RST 1.43246a
Cext_859 \$46 SPIKE 9.17717a
Cext_860 \$46 VDD 680.269a
Cext_861 \$46 Vref 4.5106f
Cext_862 \$46 VSS 283.39a
Cext_863 \$46 sub! 1.61793f
Cext_864 \$46 Vx 3.77113a
Cext_865 \$47 \$48 0.167938a
Cext_866 \$47 SPIKE 0.766966a
Cext_867 \$47 Vref 9.71291a
Cext_868 \$47 VSS 130.507a
Cext_869 \$47 sub! 15.9371a
Cext_870 \$48 \$49 7.88112a
Cext_871 \$48 \$50 232.784a
Cext_872 \$48 \$51 18.6178a
Cext_873 \$48 \$52 1.38144a
Cext_874 \$48 \$7 1.1751a
Cext_875 \$48 \$76 670.963a
Cext_876 \$48 \$77 855.685a
Cext_877 \$48 \$78 18.0496a
Cext_878 \$48 \$8 1.16999a
Cext_879 \$48 \$9 0.161751a
Cext_880 \$48 VDD 474.894a
Cext_881 \$48 Vref 7.68672a
Cext_882 \$48 VSS 309.82a
Cext_883 \$48 sub! 514.307a
Cext_884 \$49 \$50 98.0717a
Cext_885 \$49 \$76 21.0101a
Cext_886 \$49 \$77 12.4674a
Cext_887 \$49 VSS 120.012a
Cext_888 \$49 sub! 15.4142a
Cext_889 \$5 RST 39.3523a
Cext_890 \$5 SPIKE 29.5963a
Cext_891 \$5 VDD 427.465a
Cext_892 \$5 VSS 275.428a
Cext_893 \$5 sub! 516.641a
Cext_894 \$5 Vx 0.492109a
Cext_895 \$50 \$51 98.0717a
Cext_896 \$50 \$52 10.6747a
Cext_897 \$50 \$76 394.069a
Cext_898 \$50 \$77 354.193a
Cext_899 \$50 \$78 200.325a
Cext_900 \$50 VDD 90.2442a
Cext_901 \$50 VSS 80.5939a
Cext_902 \$50 sub! 557.386a
Cext_903 \$51 \$77 50.6052a
Cext_904 \$51 VSS 137.684a
Cext_905 \$51 sub! 14.299a
Cext_906 \$52 \$76 0.289599a
Cext_907 \$52 \$77 1.86333a
Cext_908 \$52 \$78 461.063a
Cext_909 \$52 MEM 133.907a
Cext_910 \$52 VDD 650.383a
Cext_911 \$52 VSS 798.167a
Cext_912 \$52 sub! 565.003a
Cext_913 \$7 \$76 0.691397a
Cext_914 \$7 \$8 188.342a
Cext_915 \$7 \$9 0.83768a
Cext_916 \$7 RST 218.059a
Cext_917 \$7 SPIKE 306.383a
Cext_918 \$7 VDD 521.881a
Cext_919 \$7 Vref 2.88346a
Cext_920 \$7 VSS 300.685a
Cext_921 \$7 sub! 1.05184f
Cext_922 \$76 \$77 852.299a
Cext_923 \$76 \$78 9.59038a
Cext_924 \$76 \$8 1.70218a
Cext_925 \$76 SPIKE 0.579435a
Cext_926 \$76 VDD 685.251a
Cext_927 \$76 Vref 76.4529a
Cext_928 \$76 VSS 231.862a
Cext_929 \$76 sub! 1.62962f
Cext_930 \$76 Vx 184.184a
Cext_931 \$77 \$78 4.39193a
Cext_932 \$77 \$8 1.72559a
Cext_933 \$77 \$9 3.52853a
Cext_934 \$77 VDD 379.798a
Cext_935 \$77 Vref 0.122407a
Cext_936 \$77 VSS 263.98a
Cext_937 \$77 sub! 439.185a
Cext_938 \$78 MEM 0.334789a
Cext_939 \$78 VDD 565.164a
Cext_940 \$78 VSS 356.254a
Cext_941 \$78 sub! 1.13376f
Cext_942 \$8 \$9 184.873a
Cext_943 \$8 RST 25.1581a
Cext_944 \$8 SPIKE 0.452442a
Cext_945 \$8 VDD 392.657a
Cext_946 \$8 VSS 257.645a
Cext_947 \$8 sub! 533.71a
Cext_948 \$9 RST 327.479a
Cext_949 \$9 SPIKE 0.27859a
Cext_950 \$9 VDD 510.757a
Cext_951 \$9 VSS 47.075a
Cext_952 \$9 sub! 448.276a
Cext_953 MEM RST 0.453984a
Cext_954 MEM VDD 5.47851f
Cext_955 MEM VSS 2.50743f
Cext_956 MEM sub! 3.75805f
Cext_957 RST SPIKE 75.496a
Cext_958 RST VDD 243.841a
Cext_959 RST VSS 21.128a
Cext_960 RST sub! 1.00786f
Cext_961 SPIKE VDD 629.899a
Cext_962 SPIKE Vref 22.2355a
Cext_963 SPIKE VSS 534.601a
Cext_964 SPIKE sub! 476.63a
Cext_965 SPIKE Vx 0.465718a
Cext_966 VDD Vref 69.1152a
Cext_967 VDD VSS 3.97336f
Cext_968 VDD sub! 17.4547f
Cext_969 VDD Vx 166.827a
Cext_970 Vref Vx 123.023a
Cext_971 VSS Vref 386.458a
Cext_972 VSS sub! 19.0361f
Cext_973 VSS Vx 399.964a
Cext_974 sub! Vref 1.60178f
Cext_975 sub! Vx 2.77019f
.ENDS LIF_neuron
