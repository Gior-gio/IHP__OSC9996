* NGSPICE file created from LIF_neuron.ext - technology: ihp-sg13g2

.subckt nmos$3$2 a_n932_n1036# VSUB a_n906_n1000# a_n1000_n1000#
X0 a_n906_n1000# a_n932_n1036# a_n1000_n1000# VSUB sg13_lv_nmos ad=0.34p pd=2.68u as=0.34p ps=2.68u w=1u l=0.13u
.ends

.subckt nmos$2 a_n932_n1036# VSUB a_n906_n1000# a_n1000_n1000#
X0 a_n906_n1000# a_n932_n1036# a_n1000_n1000# VSUB sg13_lv_nmos ad=0.34p pd=2.68u as=0.34p ps=2.68u w=1u l=0.13u
.ends

.subckt pmos$3 a_n932_n1036# a_n906_n1000# a_n1000_n1000# w_n1062_n1062#
X0 a_n906_n1000# a_n932_n1036# a_n1000_n1000# w_n1062_n1062# sg13_lv_pmos ad=0.68p pd=4.68u as=0.68p ps=4.68u w=2u l=0.13u
.ends

.subckt rppd$7 a_n1000_n1086# a_n1000_n900#
X0 a_n1000_n900# a_n1000_n1086# rppd l=0.5u w=0.5u
.ends

.subckt rppd a_n1000_n1086# a_n1000_n900#
X0 a_n1000_n900# a_n1000_n1086# rppd l=0.5u w=0.5u
.ends

.subckt pmos$5$7 a_n932_n1036# a_n906_n1000# a_n1000_n1000# w_n1062_n1062#
X0 a_n906_n1000# a_n932_n1036# a_n1000_n1000# w_n1062_n1062# sg13_lv_pmos ad=0.68p pd=4.68u as=0.68p ps=4.68u w=2u l=0.13u
.ends

.subckt pmos$2$7 a_n932_n1036# a_n906_n1000# a_n1000_n1000# w_n1062_n1062#
X0 a_n906_n1000# a_n932_n1036# a_n1000_n1000# w_n1062_n1062# sg13_lv_pmos ad=0.68p pd=4.68u as=0.68p ps=4.68u w=2u l=0.13u
.ends

.subckt nmos$1$3$1$7 a_2094_n1000# a_2068_n1036# VSUB a_2000_n1000#
X0 a_2094_n1000# a_2068_n1036# a_2000_n1000# VSUB sg13_lv_nmos ad=0.34p pd=2.68u as=0.34p ps=2.68u w=1u l=0.13u
.ends

.subckt nmos$1$3$1 a_2094_n1000# a_2068_n1036# VSUB a_2000_n1000#
X0 a_2094_n1000# a_2068_n1036# a_2000_n1000# VSUB sg13_lv_nmos ad=0.34p pd=2.68u as=0.34p ps=2.68u w=1u l=0.13u
.ends

.subckt nmos$3$9 a_n932_n1036# VSUB a_n906_n1000# a_n1000_n1000#
X0 a_n906_n1000# a_n932_n1036# a_n1000_n1000# VSUB sg13_lv_nmos ad=0.34p pd=2.68u as=0.34p ps=2.68u w=1u l=0.13u
.ends

.subckt pmos$1$10 a_n932_n1036# a_n906_n1000# a_n1000_n1000# w_n1062_n1062#
X0 a_n906_n1000# a_n932_n1036# a_n1000_n1000# w_n1062_n1062# sg13_lv_pmos ad=0.68p pd=4.68u as=0.68p ps=4.68u w=2u l=0.13u
.ends

.subckt pmos$1$9 a_n932_n1036# a_n802_n1000# a_n1000_n1000# w_n1062_n1062#
X0 a_n802_n1000# a_n932_n1036# a_n1000_n1000# w_n1062_n1062# sg13_lv_pmos ad=0.68p pd=4.68u as=0.68p ps=4.68u w=2u l=0.65u
.ends

.subckt pmos$6 a_68_n36# w_n62_n62# a_94_0# a_0_0#
X0 a_94_0# a_68_n36# a_0_0# w_n62_n62# sg13_lv_pmos ad=0.68p pd=4.68u as=0.68p ps=4.68u w=2u l=0.13u
.ends

.subckt nmos$4$1 a_n932_n1036# a_n802_n1000# VSUB a_n1000_n1000#
X0 a_n802_n1000# a_n932_n1036# a_n1000_n1000# VSUB sg13_lv_nmos ad=0.34p pd=2.68u as=0.34p ps=2.68u w=1u l=0.65u
.ends

.subckt pmos$4$1$7 a_2094_n1000# w_1938_n1062# a_2068_n1036# a_2000_n1000#
X0 a_2094_n1000# a_2068_n1036# a_2000_n1000# w_1938_n1062# sg13_lv_pmos ad=0.68p pd=4.68u as=0.68p ps=4.68u w=2u l=0.13u
.ends

.subckt rhigh$4 a_0_800# a_0_n86#
X0 a_0_800# a_0_n86# rhigh l=4u w=0.5u
.ends

.subckt pmos$4 a_2094_n1000# w_1938_n1062# a_2068_n1036# a_2000_n1000#
X0 a_2094_n1000# a_2068_n1036# a_2000_n1000# w_1938_n1062# sg13_lv_pmos ad=0.68p pd=4.68u as=0.68p ps=4.68u w=2u l=0.13u
.ends

.subckt nmos$1$3$8 a_2094_n1000# a_2068_n1036# VSUB a_2000_n1000#
X0 a_2094_n1000# a_2068_n1036# a_2000_n1000# VSUB sg13_lv_nmos ad=0.34p pd=2.68u as=0.34p ps=2.68u w=1u l=0.13u
.ends

.subckt pmos$2 a_n932_n1036# a_n906_n1000# a_n1000_n1000# w_n1062_n1062#
X0 a_n906_n1000# a_n932_n1036# a_n1000_n1000# w_n1062_n1062# sg13_lv_pmos ad=0.68p pd=4.68u as=0.68p ps=4.68u w=2u l=0.13u
.ends

.subckt nmos$5 a_n932_n1036# a_n802_n1000# VSUB a_n1000_n1000#
X0 a_n802_n1000# a_n932_n1036# a_n1000_n1000# VSUB sg13_lv_nmos ad=0.34p pd=2.68u as=0.34p ps=2.68u w=1u l=0.65u
.ends

.subckt nmos$3 a_n932_n1036# VSUB a_n906_n1000# a_n1000_n1000#
X0 a_n906_n1000# a_n932_n1036# a_n1000_n1000# VSUB sg13_lv_nmos ad=0.34p pd=2.68u as=0.34p ps=2.68u w=1u l=0.13u
.ends

.subckt nmos a_68_n36# VSUB a_94_0# a_0_0#
X0 a_94_0# a_68_n36# a_0_0# VSUB sg13_lv_nmos ad=0.34p pd=2.68u as=0.34p ps=2.68u w=1u l=0.13u
.ends

.subckt nmos$2$7 a_n932_n1036# VSUB a_n906_n1000# a_n1000_n1000#
X0 a_n906_n1000# a_n932_n1036# a_n1000_n1000# VSUB sg13_lv_nmos ad=0.34p pd=2.68u as=0.34p ps=2.68u w=1u l=0.13u
.ends

.subckt nmos$1 a_68_n36# VSUB a_94_0# a_0_0#
X0 a_94_0# a_68_n36# a_0_0# VSUB sg13_lv_nmos ad=0.34p pd=2.68u as=0.34p ps=2.68u w=1u l=0.13u
.ends

.subckt pmos$4$1 a_2094_n1000# w_1938_n1062# a_2068_n1036# a_2000_n1000#
X0 a_2094_n1000# a_2068_n1036# a_2000_n1000# w_1938_n1062# sg13_lv_pmos ad=0.68p pd=4.68u as=0.68p ps=4.68u w=2u l=0.13u
.ends

.subckt pmos$5 a_n932_n1036# a_n906_n1000# a_n1000_n1000# w_n1062_n1062#
X0 a_n906_n1000# a_n932_n1036# a_n1000_n1000# w_n1062_n1062# sg13_lv_pmos ad=0.68p pd=4.68u as=0.68p ps=4.68u w=2u l=0.13u
.ends

.subckt pmos$1$8 a_n932_n1036# a_n802_n1000# a_n1000_n1000# w_n1062_n1062#
X0 a_n802_n1000# a_n932_n1036# a_n1000_n1000# w_n1062_n1062# sg13_lv_pmos ad=0.68p pd=4.68u as=0.68p ps=4.68u w=2u l=0.65u
.ends

.subckt pmos$4$8 a_2094_n1000# w_1938_n1062# a_2068_n1036# a_2000_n1000#
X0 a_2094_n1000# a_2068_n1036# a_2000_n1000# w_1938_n1062# sg13_lv_pmos ad=0.68p pd=4.68u as=0.68p ps=4.68u w=2u l=0.13u
.ends

.subckt nmos$6 a_68_n36# VSUB a_94_0# a_0_0#
X0 a_94_0# a_68_n36# a_0_0# VSUB sg13_lv_nmos ad=0.34p pd=2.68u as=0.34p ps=2.68u w=1u l=0.13u
.ends

.subckt pmos a_68_n36# w_n62_n62# a_94_0# a_0_0#
X0 a_94_0# a_68_n36# a_0_0# w_n62_n62# sg13_lv_pmos ad=0.68p pd=4.68u as=0.68p ps=4.68u w=2u l=0.13u
.ends

.subckt pmos$1 a_68_n36# w_n62_n62# a_94_0# a_0_0#
X0 a_94_0# a_68_n36# a_0_0# w_n62_n62# sg13_lv_pmos ad=0.68p pd=4.68u as=0.68p ps=4.68u w=2u l=0.13u
.ends

.subckt nmos$4 a_68_n36# VSUB a_94_0# a_0_0#
X0 a_94_0# a_68_n36# a_0_0# VSUB sg13_lv_nmos ad=0.34p pd=2.68u as=0.34p ps=2.68u w=1u l=0.13u
.ends

.subckt nmos$1$5 a_n932_n1036# VSUB a_n906_n1000# a_n1000_n1000#
X0 a_n906_n1000# a_n932_n1036# a_n1000_n1000# VSUB sg13_lv_nmos ad=0.34p pd=2.68u as=0.34p ps=2.68u w=1u l=0.13u
.ends

.subckt nmos$1$3 a_2094_n1000# a_2068_n1036# VSUB a_2000_n1000#
X0 a_2094_n1000# a_2068_n1036# a_2000_n1000# VSUB sg13_lv_nmos ad=0.34p pd=2.68u as=0.34p ps=2.68u w=1u l=0.13u
.ends

.subckt LIF_neuron VDD SPIKE VSS Vref Vctr VOUT vCMP Ven
Xnmos$3$2_5 a_3427_8420# VSS m1_3530_8525# VSS nmos$3$2
Xnmos$2_3 a_3085_8317# VSS VSS nmos$2_2/a_n906_n1000# nmos$2
Xpmos$3_25 a_2511_6184# pmos$3_25/a_n906_n1000# a_1343_9631# VDD pmos$3
Xrppd$7_15 m1_3530_9631# VOUT rppd$7
Xpmos$3_14 VDD VDD a_2307_8412# VDD pmos$3
Xrppd_9 VSS VSS rppd
Xpmos$5$7_3 a_3427_7490# m1_3530_7403# VDD VDD pmos$5$7
Xpmos$2$7_6 a_2842_7402# a_3233_7586# pmos$2$7_7/a_n906_n1000# VDD pmos$2$7
Xnmos$3$2_6 a_3427_8420# VSS VSS m1_3530_8525# nmos$3$2
Xnmos$2_4 a_2307_6184# VSS nmos$2_4/a_n906_n1000# VSS nmos$2
Xpmos$3_26 VDD VDD a_1343_9631# VDD pmos$3
Xrppd$7_16 VSS VSS rppd$7
Xpmos$5$7_4 a_3427_9718# VDD m1_3530_9631# VDD pmos$5$7
Xpmos$3_15 a_917_7403# VDD pmos$3_17/a_n906_n1000# VDD pmos$3
Xnmos$1$3$1$7_0 a_2842_7402# a_2511_7498# VSS VSS nmos$1$3$1$7
Xnmos$1$3$1_0 a_2842_6280# a_2511_6184# VSS VSS nmos$1$3$1
Xpmos$2$7_7 a_1915_6087# pmos$2$7_7/a_n906_n1000# VDD VDD pmos$2$7
Xnmos$3$2_7 a_3427_8420# VSS m1_3530_8525# VSS nmos$3$2
Xnmos$2_5 a_2307_8412# VSS nmos$2_5/a_n906_n1000# VSS nmos$2
Xnmos$3$9_0 a_3427_7490# VSS m1_3530_7403# VSS nmos$3$9
Xpmos$1$10_0 vCMP a_2769_5180# VDD VDD pmos$1$10
Xpmos$3_27 a_2307_6184# pmos$3_27/a_n906_n1000# a_1915_9631# VDD pmos$3
Xpmos$3_16 VDD VDD a_1915_8315# VDD pmos$3
Xnmos$1$3$1$7_1 a_2842_9630# a_1343_8315# VSS VSS nmos$1$3$1$7
Xrppd$7_17 VSS VSS rppd$7
Xpmos$5$7_5 a_3427_9718# m1_3530_9631# VDD VDD pmos$5$7
Xnmos$2_10 a_2511_8412# VSS a_3233_8324# nmos$2_5/a_n906_n1000# nmos$2
Xpmos$1$9_0 a_3207_5181# a_2840_5276# VDD VDD pmos$1$9
Xnmos$1$3$1_1 a_2842_8508# a_2511_8412# VSS VSS nmos$1$3$1
Xnmos$3$9_1 a_3427_7490# VSS VSS m1_3530_7403# nmos$3$9
Xnmos$3$2_8 a_3427_10648# VSS VSS m1_3530_10753# nmos$3$2
Xnmos$2_6 a_1915_9631# VSS nmos$2_6/a_n906_n1000# VSS nmos$2
Xpmos$1$10_1 a_2840_5276# a_2769_5180# VDD VDD pmos$1$10
Xpmos$3_28 a_917_7403# VDD pmos$3_27/a_n906_n1000# VDD pmos$3
Xrppd$7_18 VSS VSS rppd$7
Xpmos$5$7_6 a_3427_9718# m1_3530_9631# VDD VDD pmos$5$7
Xpmos$3_17 a_1915_9631# pmos$3_17/a_n906_n1000# a_1915_8315# VDD pmos$3
Xrppd$7_0 VSS VSS rppd$7
Xpmos$6_0 Ven VDD a_1692_5181# pmos$6_0/a_0_0# pmos$6
Xnmos$4$1_0 vCMP a_4221_5181# VSS VSS nmos$4$1
Xnmos$2_11 a_2511_6184# VSS a_3233_6096# nmos$2_4/a_n906_n1000# nmos$2
Xnmos$3$2_9 a_3427_10648# VSS m1_3530_10753# VSS nmos$3$2
Xnmos$2_7 a_2842_10736# VSS nmos$2_7/a_n906_n1000# a_3233_10552# nmos$2
Xnmos$1$3$1_2 a_2842_10736# a_1343_9631# VSS VSS nmos$1$3$1
Xnmos$3$9_2 a_3427_7490# VSS m1_3530_7403# VSS nmos$3$9
Xpmos$4$1$7_0 a_2842_7402# VDD a_2511_7498# VDD pmos$4$1$7
Xpmos$1$10_2 a_2769_5180# a_2538_5181# VDD VDD pmos$1$10
Xpmos$3_29 VDD VDD a_1915_9631# VDD pmos$3
Xpmos$3_18 VDD VDD a_1343_8315# VDD pmos$3
Xrppd$7_19 VSS VSS rppd$7
Xpmos$5$7_7 a_3233_9814# a_3427_9718# VDD VDD pmos$5$7
Xrppd$7_1 m1_3530_7403# VOUT rppd$7
Xpmos$6_1 a_2130_5175# VDD SPIKE VDD pmos$6
Xnmos$4$1_1 a_4221_5181# a_3883_5181# VSS VSS nmos$4$1
Xrhigh$4_10 VDD VDD rhigh$4
Xnmos$2_8 a_3085_10545# VSS VSS nmos$2_7/a_n906_n1000# nmos$2
Xpmos$4$1$7_1 a_2842_9630# VDD a_1343_8315# VDD pmos$4$1$7
Xnmos$3$9_3 a_3233_7586# VSS a_3427_7490# VSS nmos$3$9
Xpmos$3_19 VDD VDD a_2511_8412# VDD pmos$3
Xrppd$7_2 m1_3530_7403# VOUT rppd$7
Xpmos$6_2 a_2130_5175# VDD SPIKE VDD pmos$6
Xnmos$4$1_2 a_3883_5181# a_3545_5181# VSS VSS nmos$4$1
Xnmos$2_9 a_1343_9631# VSS a_3233_10552# nmos$2_6/a_n906_n1000# nmos$2
Xnmos$3$9_4 a_3427_9718# VSS VSS m1_3530_9631# nmos$3$9
Xrhigh$4_11 VDD VDD rhigh$4
Xrppd$7_3 VSS VSS rppd$7
Xpmos$6_3 a_2130_5175# VDD VDD SPIKE pmos$6
Xrppd_30 VSS VSS rppd
Xnmos$4$1_3 a_3545_5181# a_3207_5181# VSS VSS nmos$4$1
Xpmos$4_0 a_3085_6089# VDD a_2307_6184# VDD pmos$4
Xrhigh$4_12 m1_865_11602# m1_1906_11581# rhigh$4
Xnmos$3$9_5 a_3427_9718# VSS m1_3530_9631# VSS nmos$3$9
Xpmos$4_1 a_3085_8317# VDD a_2307_8412# VDD pmos$4
Xrppd$7_4 VSS VSS rppd$7
Xpmos$6_4 a_2538_5181# VDD a_2130_5175# VDD pmos$6
Xnmos$3$9_6 a_3233_9814# VSS a_3427_9718# VSS nmos$3$9
Xrppd_20 m1_3530_8525# VOUT rppd
Xrppd_31 VSS VSS rppd
Xrhigh$4_13 m1_2823_11757# m1_1906_11581# rhigh$4
Xrppd$7_5 VSS VSS rppd$7
Xpmos$6_5 a_1479_5181# VDD a_1071_5181# VDD pmos$6
Xrppd_21 VSS VSS rppd
Xpmos$4_2 a_3085_10545# VDD a_1915_9631# VDD pmos$4
Xrppd_32 VSS VSS rppd
Xnmos$1$3$8_0 a_3085_7403# a_1915_6087# VSS VSS nmos$1$3$8
Xrppd_10 VSS VSS rppd
Xrhigh$4_14 VDD VDD rhigh$4
Xnmos$3$9_7 a_3427_9718# VSS m1_3530_9631# VSS nmos$3$9
Xnmos$1$3$8_1 a_3085_9631# a_1915_8315# VSS VSS nmos$1$3$8
Xrppd$7_6 VSS VSS rppd$7
Xpmos$6_6 a_1071_5181# VDD VDD Ven pmos$6
Xrppd_33 VSS VSS rppd
Xrppd_22 VSS VSS rppd
Xrppd_11 VSS VSS rppd
Xpmos$2_0 a_3085_6089# VDD pmos$2_4/a_n906_n1000# VDD pmos$2
Xrhigh$4_15 VDD VDD rhigh$4
Xrppd$7_7 VSS VSS rppd$7
Xpmos$6_7 a_1071_5181# VDD Ven VDD pmos$6
Xnmos$5_0 a_3207_5181# a_2840_5276# VSS VSS nmos$5
Xrppd_23 VSS VSS rppd
Xrppd_34 VSS VSS rppd
Xrppd_12 VSS VSS rppd
Xpmos$2_1 a_3085_8317# VDD pmos$2_6/a_n906_n1000# VDD pmos$2
Xrppd$7_8 VSS VSS rppd$7
Xpmos$6_8 a_1071_5181# VDD Ven VDD pmos$6
Xrppd_35 VSS VSS rppd
Xrppd_24 VSS VSS rppd
Xpmos$2_2 a_3085_10545# VDD pmos$2_3/a_n906_n1000# VDD pmos$2
Xrppd_13 VSS VSS rppd
Xrppd$7_9 VSS VSS rppd$7
Xrppd_25 VSS VSS rppd
Xpmos$6_9 a_1692_5181# VDD VDD a_1479_5181# pmos$6
Xrppd_14 m1_3530_6297# VOUT rppd
Xpmos$2_3 a_1343_9631# pmos$2_3/a_n906_n1000# a_3233_10552# VDD pmos$2
Xnmos$3_0 Ven VSS VSS a_2307_6184# nmos$3
Xrppd_26 m1_3530_10753# VOUT rppd
Xnmos$3_20 a_1915_9631# VSS nmos$3_20/a_n906_n1000# a_1915_8315# nmos$3
Xrppd_15 VSS VSS rppd
Xpmos$2_4 a_2511_6184# pmos$2_4/a_n906_n1000# a_3233_6096# VDD pmos$2
Xnmos$3_1 Vref VSS VSS nmos$3_2/a_n906_n1000# nmos$3
Xnmos$3_21 VSS VSS VSS a_1343_8315# nmos$3
Xnmos$3_10 a_2511_8412# VSS nmos$3_7/a_n1000_n1000# a_2511_7498# nmos$3
Xrppd_27 m1_3530_10753# VOUT rppd
Xrppd_16 VSS VSS rppd
Xpmos$2_5 a_2842_8508# a_3233_8324# pmos$2_7/a_n906_n1000# VDD pmos$2
Xnmos_0 a_4828_5366# VSS vCMP VSS nmos
Xnmos$3_2 a_1915_6087# VSS nmos$3_2/a_n906_n1000# a_2307_6184# nmos$3
Xrppd_28 VSS VSS rppd
Xnmos$3_22 Vctr VSS VSS nmos$3_23/a_n906_n1000# nmos$3
Xrppd_17 m1_3530_8525# VOUT rppd
Xpmos$2_6 a_2511_8412# pmos$2_6/a_n906_n1000# a_3233_8324# VDD pmos$2
Xnmos$3_11 Vctr VSS VSS nmos$3_8/a_n906_n1000# nmos$3
Xnmos$2$7_0 a_2842_7402# VSS nmos$2$7_0/a_n906_n1000# a_3233_7586# nmos$2$7
Xnmos_1 a_4828_5366# VSS VSS vCMP nmos
Xnmos$1_0 vCMP VSS VSS a_1692_5181# nmos$1
Xnmos$3_3 a_2511_7498# VSS nmos$3_3/a_n906_n1000# a_2511_6184# nmos$3
Xnmos$3_23 a_1343_9631# VSS nmos$3_23/a_n906_n1000# a_1343_8315# nmos$3
Xrppd_18 VSS VSS rppd
Xrppd_29 VSS VSS rppd
Xpmos$2_7 a_2307_8412# pmos$2_7/a_n906_n1000# VDD VDD pmos$2
Xnmos$3_12 Vref VSS VSS nmos$3_13/a_n906_n1000# nmos$3
Xnmos_2 VOUT VSS a_4828_5366# VSS nmos
Xnmos$2$7_1 a_3085_7403# VSS VSS nmos$2$7_0/a_n906_n1000# nmos$2$7
Xnmos$3_4 Vctr VSS VSS nmos$3_3/a_n906_n1000# nmos$3
Xnmos$3_24 Ven VSS VSS a_1343_9631# nmos$3
Xrppd_19 VSS VSS rppd
Xnmos$3_13 a_2307_8412# VSS nmos$3_13/a_n906_n1000# a_1915_6087# nmos$3
Xnmos$1_1 Ven VSS VSS a_1692_5181# nmos$1
Xpmos$2_8 a_1915_9631# pmos$2_8/a_n906_n1000# VDD VDD pmos$2
Xnmos_3 VOUT VSS VSS a_4828_5366# nmos
Xpmos$4$1_0 a_2842_6280# VDD a_2511_6184# VDD pmos$4$1
Xnmos$2$7_2 a_1915_6087# VSS nmos$2$7_2/a_n906_n1000# VSS nmos$2$7
Xnmos$1_2 a_1692_5181# VSS VSS a_1479_5181# nmos$1
Xnmos$3_5 Ven VSS VSS a_2511_6184# nmos$3
Xpmos$2_9 a_2842_10736# a_3233_10552# pmos$2_8/a_n906_n1000# VDD pmos$2
Xnmos$3_25 a_2511_6184# VSS nmos$3_25/a_n906_n1000# a_1343_9631# nmos$3
Xnmos$3_14 VSS VSS VSS a_1915_6087# nmos$3
Xnmos$2$7_3 a_1915_8315# VSS nmos$2$7_3/a_n906_n1000# VSS nmos$2$7
Xpmos$4$1_1 a_2842_8508# VDD a_2511_8412# VDD pmos$4$1
Xnmos$3_6 Ven VSS VSS a_2511_8412# nmos$3
Xnmos$3_26 Vctr VSS VSS nmos$3_25/a_n906_n1000# nmos$3
Xnmos$3_15 Ven VSS VSS a_2307_8412# nmos$3
Xpmos$4$1_2 a_2842_10736# VDD a_1343_9631# VDD pmos$4$1
Xpmos$2_10 a_2842_6280# a_3233_6096# pmos$2_11/a_n906_n1000# VDD pmos$2
Xnmos$2$7_4 a_3085_9631# VSS VSS nmos$2$7_5/a_n906_n1000# nmos$2$7
Xnmos$3_7 Vctr VSS VSS nmos$3_7/a_n1000_n1000# nmos$3
Xrhigh$4_0 m1_1772_11581# m1_865_11602# rhigh$4
Xpmos$5_10 a_3427_10648# VDD m1_3530_10753# VDD pmos$5
Xnmos$3_27 Ven VSS VSS a_1915_9631# nmos$3
Xnmos$3_16 Vref VSS VSS nmos$3_17/a_n906_n1000# nmos$3
Xnmos$2$7_5 a_2842_9630# VSS nmos$2$7_5/a_n906_n1000# a_3233_9814# nmos$2$7
Xpmos$2_11 a_2307_6184# pmos$2_11/a_n906_n1000# VDD VDD pmos$2
Xnmos$3_8 a_1343_8315# VSS nmos$3_8/a_n906_n1000# a_2511_8412# nmos$3
Xpmos$5_11 a_3233_10552# a_3427_10648# VDD VDD pmos$5
Xnmos$3_28 a_2307_6184# VSS nmos$3_28/a_n906_n1000# a_1915_9631# nmos$3
Xnmos$3_17 a_1915_8315# VSS nmos$3_17/a_n906_n1000# a_2307_8412# nmos$3
Xrhigh$4_1 m1_1772_11581# Vctr rhigh$4
Xpmos$1$8_0 vCMP a_4221_5181# VDD VDD pmos$1$8
Xnmos$2$7_6 a_1343_8315# VSS a_3233_9814# nmos$2$7_3/a_n906_n1000# nmos$2$7
Xnmos$3_9 VSS VSS VSS a_2511_7498# nmos$3
Xrhigh$4_2 VDD VDD rhigh$4
Xnmos$3_29 Vref VSS VSS nmos$3_28/a_n906_n1000# nmos$3
Xnmos$3_18 VSS VSS VSS a_1915_8315# nmos$3
Xnmos$2$7_7 a_2511_7498# VSS a_3233_7586# nmos$2$7_2/a_n906_n1000# nmos$2$7
Xpmos$1$8_1 a_3545_5181# a_3207_5181# VDD VDD pmos$1$8
Xpmos$5_0 a_3427_6192# m1_3530_6297# VDD VDD pmos$5
Xnmos$3_19 Vref VSS VSS nmos$3_20/a_n906_n1000# nmos$3
Xrhigh$4_3 VDD VDD rhigh$4
Xpmos$1$8_2 a_4221_5181# a_3883_5181# VDD VDD pmos$1$8
Xpmos$5_1 a_3427_6192# VDD m1_3530_6297# VDD pmos$5
Xrhigh$4_4 m1_3867_11581# m1_2959_11602# rhigh$4
Xpmos$4$8_0 a_3085_7403# VDD a_1915_6087# VDD pmos$4$8
Xpmos$1$8_3 a_3883_5181# a_3545_5181# VDD VDD pmos$1$8
Xpmos$5_2 a_3233_6096# a_3427_6192# VDD VDD pmos$5
Xrhigh$4_5 m1_3867_11581# m1_2823_11757# rhigh$4
Xpmos$4$8_1 a_3085_9631# VDD a_1915_8315# VDD pmos$4$8
Xpmos$5_3 a_3427_6192# m1_3530_6297# VDD VDD pmos$5
Xpmos$3_0 a_917_8508# VDD pmos$3_1/a_n906_n1000# VDD pmos$3
Xrhigh$4_6 VDD VDD rhigh$4
Xnmos$6_0 a_2130_5175# VSS SPIKE VSS nmos$6
Xpmos$5_4 a_3427_8420# m1_3530_8525# VDD VDD pmos$5
Xpmos$3_1 a_2511_8412# pmos$3_1/a_n906_n1000# a_2511_7498# VDD pmos$3
Xnmos$6_1 a_2130_5175# VSS VSS SPIKE nmos$6
Xrppd_0 VSS VSS rppd
Xrhigh$4_7 VDD VDD rhigh$4
Xpmos$5_5 a_3427_8420# VDD m1_3530_8525# VDD pmos$5
Xrppd_1 m1_3530_6297# VOUT rppd
Xpmos$3_2 VDD VDD a_2511_7498# VDD pmos$3
Xrhigh$4_8 m1_2959_11602# m1_3996_11581# rhigh$4
Xnmos$6_2 a_2130_5175# VSS SPIKE VSS nmos$6
Xpmos_0 a_917_7403# VDD a_917_7403# VDD pmos
Xpmos$5_6 a_3233_8324# a_3427_8420# VDD VDD pmos$5
Xpmos$3_3 a_917_7403# VDD pmos$3_4/a_n906_n1000# VDD pmos$3
Xpmos$1_0 a_4828_5366# VDD VDD vCMP pmos$1
Xrppd_2 VSS VSS rppd
Xrhigh$4_9 VOUT m1_3996_11581# rhigh$4
Xpmos_1 a_917_8508# VDD a_917_8508# VDD pmos
Xnmos$4_0 Vref VSS a_917_7403# VSS nmos$4
Xnmos$6_3 a_2538_5181# VSS a_2130_5175# VSS nmos$6
Xpmos$5_7 a_3427_8420# m1_3530_8525# VDD VDD pmos$5
Xrppd$7_20 VSS VSS rppd$7
Xpmos$3_4 a_2307_8412# pmos$3_4/a_n906_n1000# a_1915_6087# VDD pmos$3
Xpmos$1_1 a_4828_5366# VDD vCMP VDD pmos$1
Xnmos$1$5_0 vCMP VSS a_2769_5180# nmos$1$5_2/a_n1000_n1000# nmos$1$5
Xrppd_3 VSS VSS rppd
Xpmos$2$7_0 a_3085_7403# VDD pmos$2$7_3/a_n906_n1000# VDD pmos$2$7
Xnmos$6_4 a_1479_5181# VSS a_1071_5181# VSS nmos$6
Xnmos$4_1 Vctr VSS a_917_8508# VSS nmos$4
Xnmos$3$2_0 a_3233_6096# VSS a_3427_6192# VSS nmos$3$2
Xpmos$5_8 a_3427_10648# m1_3530_10753# VDD VDD pmos$5
Xpmos$3_20 a_917_8508# VDD pmos$3_23/a_n906_n1000# VDD pmos$3
Xpmos$3_5 VDD VDD a_1915_6087# VDD pmos$3
Xrppd$7_21 VSS VSS rppd$7
Xpmos$2$7_1 a_3085_9631# VDD pmos$2$7_2/a_n906_n1000# VDD pmos$2$7
Xrppd_4 VSS VSS rppd
Xrppd$7_10 VSS VSS rppd$7
Xpmos$1_2 VOUT VDD VDD a_4828_5366# pmos$1
Xnmos$1$5_1 a_2769_5180# VSS VSS a_2538_5181# nmos$1$5
Xnmos$6_5 a_1071_5181# VSS Ven VSS nmos$6
Xpmos$5_9 a_3427_10648# m1_3530_10753# VDD VDD pmos$5
Xnmos$3$2_1 a_3427_6192# VSS m1_3530_6297# VSS nmos$3$2
Xrppd$7_22 VSS VSS rppd$7
Xpmos$3_21 a_917_8508# VDD pmos$3_22/a_n906_n1000# VDD pmos$3
Xrppd$7_11 VSS VSS rppd$7
Xpmos$1_3 VOUT VDD a_4828_5366# VDD pmos$1
Xnmos$1$5_2 a_2840_5276# VSS VSS nmos$1$5_2/a_n1000_n1000# nmos$1$5
Xpmos$3_10 a_917_8508# VDD pmos$3_8/a_n906_n1000# VDD pmos$3
Xpmos$3_6 VDD VDD a_2307_6184# VDD pmos$3
Xpmos$2$7_2 a_1343_8315# pmos$2$7_2/a_n906_n1000# a_3233_9814# VDD pmos$2$7
Xnmos$6_6 a_1071_5181# VSS VSS Ven nmos$6
Xrppd_5 VSS VSS rppd
Xpmos$6_10 vCMP VDD VDD pmos$6_0/a_0_0# pmos$6
Xpmos$3_22 a_1343_8315# pmos$3_22/a_n906_n1000# a_2511_8412# VDD pmos$3
Xnmos$3$2_2 a_3427_6192# VSS VSS m1_3530_6297# nmos$3$2
Xnmos$2_0 a_3085_6089# VSS VSS nmos$2_1/a_n906_n1000# nmos$2
Xpmos$3_7 VDD VDD a_2511_6184# VDD pmos$3
Xpmos$3_11 a_1915_6087# pmos$3_9/a_n1000_n1000# a_2307_6184# VDD pmos$3
Xrppd$7_12 VSS VSS rppd$7
Xrppd$7_23 VSS VSS rppd$7
Xpmos$5$7_0 a_3427_7490# m1_3530_7403# VDD VDD pmos$5$7
Xnmos$1$3_0 a_3085_6089# a_2307_6184# VSS VSS nmos$1$3
Xrppd_6 VSS VSS rppd
Xpmos$2$7_3 a_2511_7498# pmos$2$7_3/a_n906_n1000# a_3233_7586# VDD pmos$2$7
Xnmos$6_7 a_1071_5181# VSS Ven VSS nmos$6
Xnmos$2_1 a_2842_6280# VSS nmos$2_1/a_n906_n1000# a_3233_6096# nmos$2
Xnmos$3$2_3 a_3427_6192# VSS m1_3530_6297# VSS nmos$3$2
Xrppd$7_13 VSS VSS rppd$7
Xpmos$3_23 a_1343_9631# pmos$3_23/a_n906_n1000# a_1343_8315# VDD pmos$3
Xpmos$3_12 a_917_7403# VDD pmos$3_13/a_n906_n1000# VDD pmos$3
Xpmos$3_8 a_2511_7498# pmos$3_8/a_n906_n1000# a_2511_6184# VDD pmos$3
Xnmos$3$2_10 a_3233_10552# VSS a_3427_10648# VSS nmos$3$2
Xpmos$2$7_4 a_2842_9630# a_3233_9814# pmos$2$7_5/a_n906_n1000# VDD pmos$2$7
Xrppd_7 VSS VSS rppd
Xnmos$1$3_1 a_3085_8317# a_2307_8412# VSS VSS nmos$1$3
Xpmos$5$7_1 a_3233_7586# a_3427_7490# VDD VDD pmos$5$7
Xnmos$3$2_4 a_3233_8324# VSS a_3427_8420# VSS nmos$3$2
Xnmos$2_2 a_2842_8508# VSS nmos$2_2/a_n906_n1000# a_3233_8324# nmos$2
Xpmos$3_9 a_917_7403# VDD pmos$3_9/a_n1000_n1000# VDD pmos$3
Xpmos$3_24 a_917_8508# VDD pmos$3_25/a_n906_n1000# VDD pmos$3
Xnmos$3$2_11 a_3427_10648# VSS m1_3530_10753# VSS nmos$3$2
Xnmos$1$3_2 a_3085_10545# a_1915_9631# VSS VSS nmos$1$3
Xrppd$7_14 m1_3530_9631# VOUT rppd$7
Xpmos$3_13 a_1915_8315# pmos$3_13/a_n906_n1000# a_2307_8412# VDD pmos$3
Xpmos$5$7_2 a_3427_7490# VDD m1_3530_7403# VDD pmos$5$7
Xrppd_8 VSS VSS rppd
Xpmos$2$7_5 a_1915_8315# pmos$2$7_5/a_n906_n1000# VDD VDD pmos$2$7
.ends
