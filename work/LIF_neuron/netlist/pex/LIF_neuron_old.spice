* PEX produced on Fri Mar 20 05:58:40 PM CET 2026 using /foss/tools/sak/sak-pex.sh with m=2 and s=1
* NGSPICE file created from LIF_neuron.ext - technology: ihp-sg13g2

.subckt LIF_neuron VDD Vx MEM RST SPIKE VSS Vref COMP
X0 VSS VSS VSS rppd l=0.5u w=0.5u
X1 VSS a_2538_4709# a_2130_4709# VSS sg13_lv_nmos ad=0.34p pd=2.68u as=0.34p ps=2.68u w=1u l=0.13u
X2 a_3521_9195# a_3317_9195# VSS VSS sg13_lv_nmos ad=0.19p pd=1.38u as=0.34p ps=2.68u w=1u l=0.13u
X3 VDD a_1071_4709# a_1003_4745# VDD sg13_lv_pmos ad=0.38p pd=2.38u as=0.68p ps=4.68u w=2u l=0.13u
X4 VSS a_2769_4709# a_2538_4709# VSS sg13_lv_nmos ad=0.19p pd=1.38u as=0.34p ps=2.68u w=1u l=0.13u
X5 VSS a_2130_4709# SPIKE VSS sg13_lv_nmos ad=0.19p pd=1.38u as=0.34p ps=2.68u w=1u l=0.13u
X6 a_3521_6967# a_3317_6967# VSS VSS sg13_lv_nmos ad=0.34p pd=2.68u as=0.19p ps=1.38u w=1u l=0.13u
X7 VSS a_3545_4709# a_3207_4709# VSS sg13_lv_nmos ad=0.34p pd=2.68u as=0.34p ps=2.68u w=1u l=0.65u
X8 VSS VSS VSS rppd l=0.5u w=0.5u
X9 VSS VSS VSS rppd l=0.5u w=0.5u
X10 a_1369_6967# a_1267_8081# a_1267_6967# VDD sg13_lv_pmos ad=0.38p pd=2.38u as=0.38p ps=2.38u w=2u l=0.13u
X11 VDD VDD VSS rhigh l=0.96u w=0.5u
X12 VDD a_917_8508# a_1369_9195# VDD sg13_lv_pmos ad=0.68p pd=4.68u as=0.38p ps=2.38u w=2u l=0.13u
X13 a_3317_6967# a_2907_6967# VSS VSS sg13_lv_nmos ad=0.34p pd=2.68u as=0.34p ps=2.68u w=1u l=0.13u
X14 a_2907_6967# a_2584_6967# a_2805_6967# VDD sg13_lv_pmos ad=0.38p pd=2.38u as=0.38p ps=2.38u w=2u l=0.13u
X15 a_2907_10309# a_2584_10309# a_2805_10831# VDD sg13_lv_pmos ad=0.38p pd=2.38u as=0.38p ps=2.38u w=2u l=0.13u
X16 a_1369_10309# a_1267_5853# a_1267_10309# VSS sg13_lv_nmos ad=0.19p pd=1.38u as=0.19p ps=1.38u w=1u l=0.13u
X17 a_3009_9195# a_1267_9195# a_2907_9195# VDD sg13_lv_pmos ad=0.38p pd=2.38u as=0.38p ps=2.38u w=2u l=0.13u
X18 a_1839_8081# VDD VDD VDD sg13_lv_pmos ad=0.38p pd=2.38u as=0.68p ps=4.68u w=2u l=0.13u
X19 a_1267_5853# a_1003_4745# VSS VSS sg13_lv_nmos ad=0.19p pd=1.38u as=0.34p ps=2.68u w=1u l=0.13u
X20 a_3521_8081# MEM VSS rppd l=0.5u w=0.5u
X21 a_1369_8081# a_1267_9195# a_1267_8081# VSS sg13_lv_nmos ad=0.19p pd=1.38u as=0.19p ps=1.38u w=1u l=0.13u
X22 VDD COMP a_4221_4709# VDD sg13_lv_pmos ad=0.68p pd=4.68u as=0.68p ps=4.68u w=2u l=0.65u
X23 VDD a_3883_4709# a_3545_4709# VDD sg13_lv_pmos ad=0.68p pd=4.68u as=0.68p ps=4.68u w=2u l=0.65u
X24 a_2907_8081# a_1267_8081# a_2805_8081# VSS sg13_lv_nmos ad=0.19p pd=1.38u as=0.19p ps=1.38u w=1u l=0.13u
X25 VSS RST a_1692_4709# VSS sg13_lv_nmos ad=0.34p pd=2.68u as=0.19p ps=1.38u w=1u l=0.13u
X26 VSS VSS VSS rppd l=0.5u w=0.5u
X27 VSS a_4828_5366# COMP VSS sg13_lv_nmos ad=0.19p pd=1.38u as=0.19p ps=1.38u w=1u l=0.13u
X28 a_3521_10309# a_3317_10309# VSS VSS sg13_lv_nmos ad=0.19p pd=1.38u as=0.34p ps=2.68u w=1u l=0.13u
X29 a_3521_6967# a_3317_6967# VDD VDD sg13_lv_pmos ad=0.68p pd=4.68u as=0.38p ps=2.38u w=2u l=0.13u
X30 VSS VSS VSS rppd l=0.5u w=0.5u
X31 a_2584_10309# a_1267_10309# VSS VSS sg13_lv_nmos ad=0.34p pd=2.68u as=0.34p ps=2.68u w=1u l=0.13u
X32 VDD a_2538_4709# a_2130_4709# VDD sg13_lv_pmos ad=0.68p pd=4.68u as=0.68p ps=4.68u w=2u l=0.13u
X33 VSS VSS VSS rppd l=0.5u w=0.5u
X34 a_3317_6967# a_2907_6967# VDD VDD sg13_lv_pmos ad=0.68p pd=4.68u as=0.68p ps=4.68u w=2u l=0.13u
X35 VSS a_3317_5853# a_3521_5853# VSS sg13_lv_nmos ad=0.19p pd=1.38u as=0.19p ps=1.38u w=1u l=0.13u
X36 a_1839_9195# VSS VSS VSS sg13_lv_nmos ad=0.19p pd=1.38u as=0.34p ps=2.68u w=1u l=0.13u
X37 a_3521_8081# a_3317_8081# VSS VSS sg13_lv_nmos ad=0.34p pd=2.68u as=0.19p ps=1.38u w=1u l=0.13u
X38 VDD a_2130_4709# SPIKE VDD sg13_lv_pmos ad=0.38p pd=2.38u as=0.68p ps=4.68u w=2u l=0.13u
X39 a_1267_8081# VDD VDD VDD sg13_lv_pmos ad=0.38p pd=2.38u as=0.68p ps=4.68u w=2u l=0.13u
X40 a_2805_10309# a_1839_10309# VSS VSS sg13_lv_nmos ad=0.19p pd=1.38u as=0.34p ps=2.68u w=1u l=0.13u
X41 a_1003_4745# a_1071_4709# VSS VSS sg13_lv_nmos ad=0.19p pd=1.38u as=0.19p ps=1.38u w=1u l=0.13u
X42 VSS a_2380_5853# a_3009_5853# VSS sg13_lv_nmos ad=0.34p pd=2.68u as=0.19p ps=1.38u w=1u l=0.13u
X43 a_3317_8081# a_2907_8081# VSS VSS sg13_lv_nmos ad=0.34p pd=2.68u as=0.34p ps=2.68u w=1u l=0.13u
X44 a_2584_5853# a_1267_5853# VSS VSS sg13_lv_nmos ad=0.34p pd=2.68u as=0.34p ps=2.68u w=1u l=0.13u
X45 VSS VSS VSS rppd l=0.5u w=0.5u
X46 VDD a_917_8508# a_1369_6375# VDD sg13_lv_pmos ad=0.68p pd=4.68u as=0.38p ps=2.38u w=2u l=0.13u
X47 VSS VSS VSS rppd l=0.5u w=0.5u
X48 a_2380_9195# a_1839_9195# VDD VDD sg13_lv_pmos ad=0.68p pd=4.68u as=0.68p ps=4.68u w=2u l=0.13u
X49 a_3009_6375# a_1267_5853# a_2907_5853# VDD sg13_lv_pmos ad=0.38p pd=2.38u as=0.38p ps=2.38u w=2u l=0.13u
X50 VSS VSS VSS rppd l=0.5u w=0.5u
X51 a_1839_10309# VDD VDD VDD sg13_lv_pmos ad=0.38p pd=2.38u as=0.68p ps=4.68u w=2u l=0.13u
X52 VSS MEM a_4828_5366# VSS sg13_lv_nmos ad=0.34p pd=2.68u as=0.19p ps=1.38u w=1u l=0.13u
X53 VSS VSS VSS rppd l=0.5u w=0.5u
X54 VDD a_3317_8081# a_3521_8081# VDD sg13_lv_pmos ad=0.38p pd=2.38u as=0.38p ps=2.38u w=2u l=0.13u
X55 a_1692_4709# RST a_1820_4745# VDD sg13_lv_pmos ad=0.68p pd=4.68u as=0.38p ps=2.38u w=2u l=0.13u
X56 a_1267_9195# VSS VSS VSS sg13_lv_nmos ad=0.19p pd=1.38u as=0.34p ps=2.68u w=1u l=0.13u
X57 VSS VSS VSS rppd l=0.5u w=0.5u
X58 a_2907_10309# a_1267_10309# a_2805_10309# VSS sg13_lv_nmos ad=0.19p pd=1.38u as=0.19p ps=1.38u w=1u l=0.13u
X59 VSS VSS VSS rppd l=0.5u w=0.5u
X60 VDD a_917_8508# a_1369_10831# VDD sg13_lv_pmos ad=0.68p pd=4.68u as=0.38p ps=2.38u w=2u l=0.13u
X61 VSS VX a_1369_7689# VSS sg13_lv_nmos ad=0.34p pd=2.68u as=0.19p ps=1.38u w=1u l=0.13u
X62 VDD a_2380_8081# a_3009_8603# VDD sg13_lv_pmos ad=0.68p pd=4.68u as=0.38p ps=2.38u w=2u l=0.13u
X63 VDD COMP a_2769_4709# VDD sg13_lv_pmos ad=0.68p pd=4.68u as=0.38p ps=2.38u w=2u l=0.13u
X64 a_2584_8081# a_1267_8081# VDD VDD sg13_lv_pmos ad=0.68p pd=4.68u as=0.68p ps=4.68u w=2u l=0.13u
X65 a_3009_7689# a_2584_6967# a_2907_6967# VSS sg13_lv_nmos ad=0.19p pd=1.38u as=0.19p ps=1.38u w=1u l=0.13u
X66 VDD VDD VSS rhigh l=0.96u w=0.5u
X67 a_3521_8081# MEM VSS rppd l=0.5u w=0.5u
X68 a_1941_5853# a_1839_6967# a_1839_5853# VSS sg13_lv_nmos ad=0.19p pd=1.38u as=0.19p ps=1.38u w=1u l=0.13u
X69 VSS a_3317_9195# a_3521_9195# VSS sg13_lv_nmos ad=0.19p pd=1.38u as=0.19p ps=1.38u w=1u l=0.13u
X70 a_917_8508# a_917_8508# VDD VDD sg13_lv_pmos ad=0.68p pd=4.68u as=0.68p ps=4.68u w=2u l=0.13u
X71 a_1003_4745# a_1071_4709# VDD VDD sg13_lv_pmos ad=0.38p pd=2.38u as=0.38p ps=2.38u w=2u l=0.13u
X72 SPIKE a_2130_4709# VSS VSS sg13_lv_nmos ad=0.19p pd=1.38u as=0.19p ps=1.38u w=1u l=0.13u
X73 a_2380_5853# a_1839_5853# VDD VDD sg13_lv_pmos ad=0.68p pd=4.68u as=0.68p ps=4.68u w=2u l=0.13u
X74 VDD a_3317_10309# a_3521_10309# VDD sg13_lv_pmos ad=0.38p pd=2.38u as=0.38p ps=2.38u w=2u l=0.13u
X75 a_2584_9195# a_1267_9195# VSS VSS sg13_lv_nmos ad=0.34p pd=2.68u as=0.34p ps=2.68u w=1u l=0.13u
X76 VSS a_2380_9195# a_3009_9917# VSS sg13_lv_nmos ad=0.34p pd=2.68u as=0.19p ps=1.38u w=1u l=0.13u
X77 VSS VSS VSS rppd l=0.5u w=0.5u
X78 VSS VSS VSS rppd l=0.5u w=0.5u
X79 VDD VDD VSS rhigh l=4u w=0.5u
X80 VDD a_917_8508# a_1369_6967# VDD sg13_lv_pmos ad=0.68p pd=4.68u as=0.38p ps=2.38u w=2u l=0.13u
X81 a_2804_11753# a_3837_11577# VSS rhigh l=4u w=0.5u
X82 a_3009_6967# a_1267_6967# a_2907_6967# VDD sg13_lv_pmos ad=0.38p pd=2.38u as=0.38p ps=2.38u w=2u l=0.13u
X83 VSS a_4221_4709# a_3883_4709# VSS sg13_lv_nmos ad=0.34p pd=2.68u as=0.34p ps=2.68u w=1u l=0.65u
X84 a_1918_11577# a_885_11577# VSS rhigh l=4u w=0.5u
X85 VSS VSS VSS rppd l=0.5u w=0.5u
X86 a_2805_9195# a_1839_9195# VDD VDD sg13_lv_pmos ad=0.38p pd=2.38u as=0.68p ps=4.68u w=2u l=0.13u
X87 a_1941_8603# a_1839_9195# a_1839_8081# VDD sg13_lv_pmos ad=0.38p pd=2.38u as=0.38p ps=2.38u w=2u l=0.13u
X88 a_1369_5853# a_1267_6967# a_1267_5853# VSS sg13_lv_nmos ad=0.19p pd=1.38u as=0.19p ps=1.38u w=1u l=0.13u
X89 VDD a_917_6931# a_1941_9195# VDD sg13_lv_pmos ad=0.68p pd=4.68u as=0.38p ps=2.38u w=2u l=0.13u
X90 VSS VX a_1369_8081# VSS sg13_lv_nmos ad=0.34p pd=2.68u as=0.19p ps=1.38u w=1u l=0.13u
X91 a_2907_5853# a_1267_5853# a_2805_5853# VSS sg13_lv_nmos ad=0.19p pd=1.38u as=0.19p ps=1.38u w=1u l=0.13u
X92 a_3009_8081# a_2584_8081# a_2907_8081# VSS sg13_lv_nmos ad=0.19p pd=1.38u as=0.19p ps=1.38u w=1u l=0.13u
X93 a_2380_6967# a_1839_6967# VSS VSS sg13_lv_nmos ad=0.34p pd=2.68u as=0.34p ps=2.68u w=1u l=0.13u
X94 VSS VSS VSS rppd l=0.5u w=0.5u
X95 a_3317_10309# a_2907_10309# VDD VDD sg13_lv_pmos ad=0.68p pd=4.68u as=0.68p ps=4.68u w=2u l=0.13u
X96 a_1839_10309# a_1003_4745# VSS VSS sg13_lv_nmos ad=0.19p pd=1.38u as=0.34p ps=2.68u w=1u l=0.13u
X97 VDD VDD VSS rhigh l=0.96u w=0.5u
X98 a_2380_10309# a_1839_10309# VDD VDD sg13_lv_pmos ad=0.68p pd=4.68u as=0.68p ps=4.68u w=2u l=0.13u
X99 VSS VSS VSS rppd l=0.5u w=0.5u
X100 a_3009_10831# a_1267_10309# a_2907_10309# VDD sg13_lv_pmos ad=0.38p pd=2.38u as=0.38p ps=2.38u w=2u l=0.13u
X101 VSS VX a_1369_10309# VSS sg13_lv_nmos ad=0.34p pd=2.68u as=0.19p ps=1.38u w=1u l=0.13u
X102 a_1941_9917# a_1839_10309# a_1839_9195# VSS sg13_lv_nmos ad=0.19p pd=1.38u as=0.19p ps=1.38u w=1u l=0.13u
X103 a_3521_9195# a_3317_9195# VDD VDD sg13_lv_pmos ad=0.38p pd=2.38u as=0.68p ps=4.68u w=2u l=0.13u
X104 VSS VSS VSS rppd l=0.5u w=0.5u
X105 SPIKE a_2130_4709# VDD VDD sg13_lv_pmos ad=0.38p pd=2.38u as=0.38p ps=2.38u w=2u l=0.13u
X106 a_3521_5853# a_3317_5853# VSS VSS sg13_lv_nmos ad=0.34p pd=2.68u as=0.19p ps=1.38u w=1u l=0.13u
X107 a_1369_8603# a_1267_9195# a_1267_8081# VDD sg13_lv_pmos ad=0.38p pd=2.38u as=0.38p ps=2.38u w=2u l=0.13u
X108 VSS VSS VSS rppd l=0.5u w=0.5u
X109 a_3317_5853# a_2907_5853# VSS VSS sg13_lv_nmos ad=0.34p pd=2.68u as=0.34p ps=2.68u w=1u l=0.13u
X110 VDD VDD VSS rhigh l=4u w=0.5u
X111 a_3984_11577# MEM VSS rhigh l=4u w=0.5u
X112 a_2907_8081# a_2584_8081# a_2805_8603# VDD sg13_lv_pmos ad=0.38p pd=2.38u as=0.38p ps=2.38u w=2u l=0.13u
X113 VSS a_1071_4709# a_1003_4745# VSS sg13_lv_nmos ad=0.34p pd=2.68u as=0.19p ps=1.38u w=1u l=0.13u
X114 a_3521_9195# MEM VSS rppd l=0.5u w=0.5u
X115 a_2380_6967# a_1839_6967# VDD VDD sg13_lv_pmos ad=0.68p pd=4.68u as=0.68p ps=4.68u w=2u l=0.13u
X116 VSS VSS VSS rppd l=0.5u w=0.5u
X117 VSS a_3317_10309# a_3521_10309# VSS sg13_lv_nmos ad=0.19p pd=1.38u as=0.19p ps=1.38u w=1u l=0.13u
X118 VSS VSS VSS rppd l=0.5u w=0.5u
X119 a_2805_6375# a_1839_5853# VDD VDD sg13_lv_pmos ad=0.38p pd=2.38u as=0.68p ps=4.68u w=2u l=0.13u
X120 a_2380_8081# a_1839_8081# VSS VSS sg13_lv_nmos ad=0.34p pd=2.68u as=0.34p ps=2.68u w=1u l=0.13u
X121 VSS VSS VSS rppd l=0.5u w=0.5u
X122 VDD a_917_6931# a_1941_6375# VDD sg13_lv_pmos ad=0.68p pd=4.68u as=0.38p ps=2.38u w=2u l=0.13u
X123 VSS VSS VSS rppd l=0.5u w=0.5u
X124 VDD VDD VSS rhigh l=4u w=0.5u
X125 VX a_1771_11577# VSS rhigh l=4u w=0.5u
X126 a_1369_9917# a_1267_10309# a_1267_9195# VSS sg13_lv_nmos ad=0.19p pd=1.38u as=0.19p ps=1.38u w=1u l=0.13u
X127 a_3521_8081# a_3317_8081# VDD VDD sg13_lv_pmos ad=0.68p pd=4.68u as=0.38p ps=2.38u w=2u l=0.13u
X128 VSS a_3207_4709# a_2840_5276# VSS sg13_lv_nmos ad=0.34p pd=2.68u as=0.34p ps=2.68u w=1u l=0.65u
X129 a_2907_9195# a_1267_9195# a_2805_9917# VSS sg13_lv_nmos ad=0.19p pd=1.38u as=0.19p ps=1.38u w=1u l=0.13u
X130 a_3317_8081# a_2907_8081# VDD VDD sg13_lv_pmos ad=0.68p pd=4.68u as=0.68p ps=4.68u w=2u l=0.13u
X131 VSS VSS VSS rppd l=0.5u w=0.5u
X132 VDD a_2769_4709# a_2538_4709# VDD sg13_lv_pmos ad=0.38p pd=2.38u as=0.68p ps=4.68u w=2u l=0.13u
X133 a_2805_7689# a_1839_6967# VSS VSS sg13_lv_nmos ad=0.19p pd=1.38u as=0.34p ps=2.68u w=1u l=0.13u
X134 a_3521_5853# a_3317_5853# VDD VDD sg13_lv_pmos ad=0.38p pd=2.38u as=0.68p ps=4.68u w=2u l=0.13u
X135 a_1941_10831# a_1839_5853# a_1839_10309# VDD sg13_lv_pmos ad=0.38p pd=2.38u as=0.38p ps=2.38u w=2u l=0.13u
X136 a_3317_10309# a_2907_10309# VSS VSS sg13_lv_nmos ad=0.34p pd=2.68u as=0.34p ps=2.68u w=1u l=0.13u
X137 a_1839_9195# VDD VDD VDD sg13_lv_pmos ad=0.38p pd=2.38u as=0.68p ps=4.68u w=2u l=0.13u
X138 VSS VSS VSS rppd l=0.5u w=0.5u
X139 VSS VREF a_1941_7689# VSS sg13_lv_nmos ad=0.34p pd=2.68u as=0.19p ps=1.38u w=1u l=0.13u
X140 VSS VSS VSS rppd l=0.5u w=0.5u
X141 VDD a_3545_4709# a_3207_4709# VDD sg13_lv_pmos ad=0.68p pd=4.68u as=0.68p ps=4.68u w=2u l=0.65u
X142 VDD VDD VSS rhigh l=4u w=0.5u
X143 a_2380_10309# a_1839_10309# VSS VSS sg13_lv_nmos ad=0.34p pd=2.68u as=0.34p ps=2.68u w=1u l=0.13u
X144 a_3521_9195# a_3317_9195# VSS VSS sg13_lv_nmos ad=0.34p pd=2.68u as=0.19p ps=1.38u w=1u l=0.13u
X145 VDD a_1071_4709# a_1003_4745# VDD sg13_lv_pmos ad=0.68p pd=4.68u as=0.38p ps=2.38u w=2u l=0.13u
X146 VSS a_2130_4709# SPIKE VSS sg13_lv_nmos ad=0.34p pd=2.68u as=0.19p ps=1.38u w=1u l=0.13u
X147 a_3009_10309# a_2584_10309# a_2907_10309# VSS sg13_lv_nmos ad=0.19p pd=1.38u as=0.19p ps=1.38u w=1u l=0.13u
X148 a_3317_9195# a_2907_9195# VSS VSS sg13_lv_nmos ad=0.34p pd=2.68u as=0.34p ps=2.68u w=1u l=0.13u
X149 VSS VSS VSS rppd l=0.5u w=0.5u
X150 a_2897_5460# a_2840_5276# VSS VSS sg13_lv_nmos ad=0.19p pd=1.38u as=0.19p ps=1.38u w=1u l=0.13u
X151 VDD VDD VSS rhigh l=0.96u w=0.5u
X152 VSS VSS VSS rppd l=0.5u w=0.5u
X153 a_3521_6967# a_3317_6967# VSS VSS sg13_lv_nmos ad=0.19p pd=1.38u as=0.34p ps=2.68u w=1u l=0.13u
X154 a_2805_6967# a_1839_6967# VDD VDD sg13_lv_pmos ad=0.38p pd=2.38u as=0.68p ps=4.68u w=2u l=0.13u
X155 VSS VSS VSS rppd l=0.5u w=0.5u
X156 a_1267_9195# VDD VDD VDD sg13_lv_pmos ad=0.38p pd=2.38u as=0.68p ps=4.68u w=2u l=0.13u
X157 VDD a_917_6931# a_1941_6967# VDD sg13_lv_pmos ad=0.68p pd=4.68u as=0.38p ps=2.38u w=2u l=0.13u
X158 VSS VX a_1369_5853# VSS sg13_lv_nmos ad=0.34p pd=2.68u as=0.19p ps=1.38u w=1u l=0.13u
X159 VDD a_2380_10309# a_3009_10831# VDD sg13_lv_pmos ad=0.68p pd=4.68u as=0.38p ps=2.38u w=2u l=0.13u
X160 a_3009_5853# a_2584_5853# a_2907_5853# VSS sg13_lv_nmos ad=0.19p pd=1.38u as=0.19p ps=1.38u w=1u l=0.13u
X161 a_3521_10309# a_3317_10309# VDD VDD sg13_lv_pmos ad=0.68p pd=4.68u as=0.38p ps=2.38u w=2u l=0.13u
X162 a_3521_9195# MEM VSS rppd l=0.5u w=0.5u
X163 a_2805_8081# a_1839_8081# VSS VSS sg13_lv_nmos ad=0.19p pd=1.38u as=0.34p ps=2.68u w=1u l=0.13u
X164 VSS VREF a_1941_8081# VSS sg13_lv_nmos ad=0.34p pd=2.68u as=0.19p ps=1.38u w=1u l=0.13u
X165 VSS a_1692_4709# a_1479_4709# VSS sg13_lv_nmos ad=0.19p pd=1.38u as=0.34p ps=2.68u w=1u l=0.13u
X166 a_1839_5853# VDD VDD VDD sg13_lv_pmos ad=0.38p pd=2.38u as=0.68p ps=4.68u w=2u l=0.13u
X167 a_1267_10309# VDD VDD VDD sg13_lv_pmos ad=0.38p pd=2.38u as=0.68p ps=4.68u w=2u l=0.13u
X168 a_3521_5853# MEM VSS rppd l=0.5u w=0.5u
X169 VSS VSS VSS rppd l=0.5u w=0.5u
X170 a_3521_6967# a_3317_6967# VDD VDD sg13_lv_pmos ad=0.38p pd=2.38u as=0.68p ps=4.68u w=2u l=0.13u
X171 VDD a_3317_9195# a_3521_9195# VDD sg13_lv_pmos ad=0.38p pd=2.38u as=0.38p ps=2.38u w=2u l=0.13u
X172 VDD a_2130_4709# SPIKE VDD sg13_lv_pmos ad=0.68p pd=4.68u as=0.38p ps=2.38u w=2u l=0.13u
X173 VSS a_3883_4709# a_3545_4709# VSS sg13_lv_nmos ad=0.34p pd=2.68u as=0.34p ps=2.68u w=1u l=0.65u
X174 VDD a_917_8508# a_1369_8603# VDD sg13_lv_pmos ad=0.68p pd=4.68u as=0.38p ps=2.38u w=2u l=0.13u
X175 VSS VSS VSS rppd l=0.5u w=0.5u
X176 VSS COMP a_4221_4709# VSS sg13_lv_nmos ad=0.34p pd=2.68u as=0.34p ps=2.68u w=1u l=0.65u
X177 VSS VSS VSS rppd l=0.5u w=0.5u
X178 a_3009_8603# a_1267_8081# a_2907_8081# VDD sg13_lv_pmos ad=0.38p pd=2.38u as=0.38p ps=2.38u w=2u l=0.13u
X179 a_3521_8081# a_3317_8081# VSS VSS sg13_lv_nmos ad=0.19p pd=1.38u as=0.34p ps=2.68u w=1u l=0.13u
X180 a_1941_10309# a_1839_5853# a_1839_10309# VSS sg13_lv_nmos ad=0.19p pd=1.38u as=0.19p ps=1.38u w=1u l=0.13u
X181 VDD a_2380_9195# a_3009_9195# VDD sg13_lv_pmos ad=0.68p pd=4.68u as=0.38p ps=2.38u w=2u l=0.13u
X182 a_2584_9195# a_1267_9195# VDD VDD sg13_lv_pmos ad=0.68p pd=4.68u as=0.68p ps=4.68u w=2u l=0.13u
X183 a_1839_6967# VSS VSS VSS sg13_lv_nmos ad=0.19p pd=1.38u as=0.34p ps=2.68u w=1u l=0.13u
X184 COMP a_4828_5366# VDD VDD sg13_lv_pmos ad=0.38p pd=2.38u as=0.68p ps=4.68u w=2u l=0.13u
X185 a_2951_11577# a_3837_11577# VSS rhigh l=4u w=0.5u
X186 a_2380_5853# a_1839_5853# VSS VSS sg13_lv_nmos ad=0.34p pd=2.68u as=0.34p ps=2.68u w=1u l=0.13u
X187 VSS VSS VSS rppd l=0.5u w=0.5u
X188 a_1267_5853# VDD VDD VDD sg13_lv_pmos ad=0.38p pd=2.38u as=0.68p ps=4.68u w=2u l=0.13u
X189 VSS VSS VSS rppd l=0.5u w=0.5u
X190 VSS VSS VSS rppd l=0.5u w=0.5u
X191 VDD VDD VSS rhigh l=0.96u w=0.5u
X192 VDD VDD VSS rhigh l=0.96u w=0.5u
X193 VSS VSS VSS rppd l=0.5u w=0.5u
X194 VDD a_917_6931# a_1941_10831# VDD sg13_lv_pmos ad=0.68p pd=4.68u as=0.38p ps=2.38u w=2u l=0.13u
X195 VSS VX a_1369_9917# VSS sg13_lv_nmos ad=0.34p pd=2.68u as=0.19p ps=1.38u w=1u l=0.13u
X196 a_3009_9917# a_2584_9195# a_2907_9195# VSS sg13_lv_nmos ad=0.19p pd=1.38u as=0.19p ps=1.38u w=1u l=0.13u
X197 VDD a_1692_4709# a_1479_4709# VDD sg13_lv_pmos ad=0.38p pd=2.38u as=0.68p ps=4.68u w=2u l=0.13u
X198 VSS VSS VSS rppd l=0.5u w=0.5u
X199 VSS a_2380_10309# a_3009_10309# VSS sg13_lv_nmos ad=0.34p pd=2.68u as=0.19p ps=1.38u w=1u l=0.13u
X200 VSS VSS VSS rppd l=0.5u w=0.5u
X201 VDD a_3317_5853# a_3521_5853# VDD sg13_lv_pmos ad=0.38p pd=2.38u as=0.38p ps=2.38u w=2u l=0.13u
X202 a_3521_10309# a_3317_10309# VSS VSS sg13_lv_nmos ad=0.34p pd=2.68u as=0.19p ps=1.38u w=1u l=0.13u
X203 a_1267_6967# VSS VSS VSS sg13_lv_nmos ad=0.19p pd=1.38u as=0.34p ps=2.68u w=1u l=0.13u
X204 VSS VSS VSS rppd l=0.5u w=0.5u
X205 a_1839_6967# VDD VDD VDD sg13_lv_pmos ad=0.38p pd=2.38u as=0.68p ps=4.68u w=2u l=0.13u
X206 a_1941_9195# a_1839_10309# a_1839_9195# VDD sg13_lv_pmos ad=0.38p pd=2.38u as=0.38p ps=2.38u w=2u l=0.13u
X207 a_2380_8081# a_1839_8081# VDD VDD sg13_lv_pmos ad=0.68p pd=4.68u as=0.68p ps=4.68u w=2u l=0.13u
X208 a_4828_5366# MEM VDD VDD sg13_lv_pmos ad=0.38p pd=2.38u as=0.38p ps=2.38u w=2u l=0.13u
X209 VSS VSS VSS rppd l=0.5u w=0.5u
X210 a_1267_10309# a_1003_4745# VSS VSS sg13_lv_nmos ad=0.19p pd=1.38u as=0.34p ps=2.68u w=1u l=0.13u
X211 VDD a_4221_4709# a_3883_4709# VDD sg13_lv_pmos ad=0.68p pd=4.68u as=0.68p ps=4.68u w=2u l=0.65u
X212 VDD a_2380_5853# a_3009_6375# VDD sg13_lv_pmos ad=0.68p pd=4.68u as=0.38p ps=2.38u w=2u l=0.13u
X213 a_1839_8081# a_1003_4745# VSS VSS sg13_lv_nmos ad=0.19p pd=1.38u as=0.34p ps=2.68u w=1u l=0.13u
X214 a_2584_5853# a_1267_5853# VDD VDD sg13_lv_pmos ad=0.68p pd=4.68u as=0.68p ps=4.68u w=2u l=0.13u
X215 a_3984_11577# a_2951_11577# VSS rhigh l=4u w=0.5u
X216 VSS VSS VSS rppd l=0.5u w=0.5u
X217 a_2769_4709# COMP a_2897_5460# VSS sg13_lv_nmos ad=0.34p pd=2.68u as=0.19p ps=1.38u w=1u l=0.13u
X218 VSS a_3317_6967# a_3521_6967# VSS sg13_lv_nmos ad=0.19p pd=1.38u as=0.19p ps=1.38u w=1u l=0.13u
X219 VSS VSS VSS rppd l=0.5u w=0.5u
X220 a_2380_9195# a_1839_9195# VSS VSS sg13_lv_nmos ad=0.34p pd=2.68u as=0.34p ps=2.68u w=1u l=0.13u
X221 a_1267_6967# VDD VDD VDD sg13_lv_pmos ad=0.38p pd=2.38u as=0.68p ps=4.68u w=2u l=0.13u
X222 a_885_11577# a_1771_11577# VSS rhigh l=4u w=0.5u
X223 a_1369_9195# a_1267_10309# a_1267_9195# VDD sg13_lv_pmos ad=0.38p pd=2.38u as=0.38p ps=2.38u w=2u l=0.13u
X224 VSS a_2380_6967# a_3009_7689# VSS sg13_lv_nmos ad=0.34p pd=2.68u as=0.19p ps=1.38u w=1u l=0.13u
X225 a_2907_9195# a_2584_9195# a_2805_9195# VDD sg13_lv_pmos ad=0.38p pd=2.38u as=0.38p ps=2.38u w=2u l=0.13u
X226 VSS VSS VSS rppd l=0.5u w=0.5u
X227 a_2584_6967# a_1267_6967# VSS VSS sg13_lv_nmos ad=0.34p pd=2.68u as=0.34p ps=2.68u w=1u l=0.13u
X228 a_2805_5853# a_1839_5853# VSS VSS sg13_lv_nmos ad=0.19p pd=1.38u as=0.34p ps=2.68u w=1u l=0.13u
X229 VSS VSS VSS rppd l=0.5u w=0.5u
X230 a_1267_8081# a_1003_4745# VSS VSS sg13_lv_nmos ad=0.19p pd=1.38u as=0.34p ps=2.68u w=1u l=0.13u
X231 VSS VREF a_1941_5853# VSS sg13_lv_nmos ad=0.34p pd=2.68u as=0.19p ps=1.38u w=1u l=0.13u
X232 a_3521_5853# MEM VSS rppd l=0.5u w=0.5u
X233 a_1692_4709# COMP VSS VSS sg13_lv_nmos ad=0.19p pd=1.38u as=0.19p ps=1.38u w=1u l=0.13u
X234 VSS VREF a_1941_10309# VSS sg13_lv_nmos ad=0.34p pd=2.68u as=0.19p ps=1.38u w=1u l=0.13u
X235 a_1941_6375# a_1839_6967# a_1839_5853# VDD sg13_lv_pmos ad=0.38p pd=2.38u as=0.38p ps=2.38u w=2u l=0.13u
X236 VDD VDD VSS rhigh l=4u w=0.5u
X237 VSS VSS VSS rppd l=0.5u w=0.5u
X238 a_917_6931# VREF VSS VSS sg13_lv_nmos ad=0.34p pd=2.68u as=0.34p ps=2.68u w=1u l=0.13u
X239 COMP a_4828_5366# VSS VSS sg13_lv_nmos ad=0.19p pd=1.38u as=0.34p ps=2.68u w=1u l=0.13u
X240 VDD a_3317_6967# a_3521_6967# VDD sg13_lv_pmos ad=0.38p pd=2.38u as=0.38p ps=2.38u w=2u l=0.13u
X241 a_3521_6967# MEM VSS rppd l=0.5u w=0.5u
X242 a_3521_9195# a_3317_9195# VDD VDD sg13_lv_pmos ad=0.68p pd=4.68u as=0.38p ps=2.38u w=2u l=0.13u
X243 VSS VSS VSS rppd l=0.5u w=0.5u
X244 a_3521_10309# MEM VSS rppd l=0.5u w=0.5u
X245 VSS VSS VSS rppd l=0.5u w=0.5u
X246 VSS a_1479_4709# a_1071_4709# VSS sg13_lv_nmos ad=0.34p pd=2.68u as=0.34p ps=2.68u w=1u l=0.13u
X247 a_3521_5853# a_3317_5853# VSS VSS sg13_lv_nmos ad=0.19p pd=1.38u as=0.34p ps=2.68u w=1u l=0.13u
X248 a_3317_9195# a_2907_9195# VDD VDD sg13_lv_pmos ad=0.68p pd=4.68u as=0.68p ps=4.68u w=2u l=0.13u
X249 a_2805_8603# a_1839_8081# VDD VDD sg13_lv_pmos ad=0.38p pd=2.38u as=0.68p ps=4.68u w=2u l=0.13u
X250 VSS a_3317_8081# a_3521_8081# VSS sg13_lv_nmos ad=0.19p pd=1.38u as=0.19p ps=1.38u w=1u l=0.13u
X251 a_2584_6967# a_1267_6967# VDD VDD sg13_lv_pmos ad=0.68p pd=4.68u as=0.68p ps=4.68u w=2u l=0.13u
X252 VDD a_2380_6967# a_3009_6967# VDD sg13_lv_pmos ad=0.68p pd=4.68u as=0.38p ps=2.38u w=2u l=0.13u
X253 VDD a_917_6931# a_1941_8603# VDD sg13_lv_pmos ad=0.68p pd=4.68u as=0.38p ps=2.38u w=2u l=0.13u
X254 VDD a_4828_5366# COMP VDD sg13_lv_pmos ad=0.38p pd=2.38u as=0.38p ps=2.38u w=2u l=0.13u
X255 a_1369_10831# a_1267_5853# a_1267_10309# VDD sg13_lv_pmos ad=0.38p pd=2.38u as=0.38p ps=2.38u w=2u l=0.13u
X256 a_1941_7689# a_1839_8081# a_1839_6967# VSS sg13_lv_nmos ad=0.19p pd=1.38u as=0.19p ps=1.38u w=1u l=0.13u
X257 VDD a_3207_4709# a_2840_5276# VDD sg13_lv_pmos ad=0.68p pd=4.68u as=0.68p ps=4.68u w=2u l=0.65u
X258 VSS a_1071_4709# a_1003_4745# VSS sg13_lv_nmos ad=0.19p pd=1.38u as=0.34p ps=2.68u w=1u l=0.13u
X259 VSS VSS VSS rppd l=0.5u w=0.5u
X260 VSS a_2380_8081# a_3009_8081# VSS sg13_lv_nmos ad=0.34p pd=2.68u as=0.19p ps=1.38u w=1u l=0.13u
X261 a_1369_6375# a_1267_6967# a_1267_5853# VDD sg13_lv_pmos ad=0.38p pd=2.38u as=0.38p ps=2.38u w=2u l=0.13u
X262 a_2584_8081# a_1267_8081# VSS VSS sg13_lv_nmos ad=0.34p pd=2.68u as=0.34p ps=2.68u w=1u l=0.13u
X263 a_917_6931# a_917_6931# VDD VDD sg13_lv_pmos ad=0.68p pd=4.68u as=0.68p ps=4.68u w=2u l=0.13u
X264 a_2907_5853# a_2584_5853# a_2805_6375# VDD sg13_lv_pmos ad=0.38p pd=2.38u as=0.38p ps=2.38u w=2u l=0.13u
X265 a_3521_6967# MEM VSS rppd l=0.5u w=0.5u
X266 VDD VDD VSS rhigh l=4u w=0.5u
X267 a_3521_10309# MEM VSS rppd l=0.5u w=0.5u
X268 a_917_8508# VX VSS VSS sg13_lv_nmos ad=0.34p pd=2.68u as=0.34p ps=2.68u w=1u l=0.13u
X269 a_1820_4745# COMP VDD VDD sg13_lv_pmos ad=0.38p pd=2.38u as=0.38p ps=2.38u w=2u l=0.13u
X270 a_4828_5366# MEM VSS VSS sg13_lv_nmos ad=0.19p pd=1.38u as=0.19p ps=1.38u w=1u l=0.13u
X271 a_1918_11577# a_2804_11753# VSS rhigh l=4u w=0.5u
X272 VDD VDD VSS rhigh l=4u w=0.5u
X273 a_2805_9917# a_1839_9195# VSS VSS sg13_lv_nmos ad=0.19p pd=1.38u as=0.34p ps=2.68u w=1u l=0.13u
X274 a_3521_8081# a_3317_8081# VDD VDD sg13_lv_pmos ad=0.38p pd=2.38u as=0.68p ps=4.68u w=2u l=0.13u
X275 a_3521_10309# a_3317_10309# VDD VDD sg13_lv_pmos ad=0.38p pd=2.38u as=0.68p ps=4.68u w=2u l=0.13u
X276 VSS VREF a_1941_9917# VSS sg13_lv_nmos ad=0.34p pd=2.68u as=0.19p ps=1.38u w=1u l=0.13u
X277 VSS VSS VSS rppd l=0.5u w=0.5u
X278 VSS VSS VSS rppd l=0.5u w=0.5u
X279 a_2584_10309# a_1267_10309# VDD VDD sg13_lv_pmos ad=0.68p pd=4.68u as=0.68p ps=4.68u w=2u l=0.13u
X280 a_3521_5853# a_3317_5853# VDD VDD sg13_lv_pmos ad=0.68p pd=4.68u as=0.38p ps=2.38u w=2u l=0.13u
X281 a_1369_7689# a_1267_8081# a_1267_6967# VSS sg13_lv_nmos ad=0.19p pd=1.38u as=0.19p ps=1.38u w=1u l=0.13u
X282 a_1941_6967# a_1839_8081# a_1839_6967# VDD sg13_lv_pmos ad=0.38p pd=2.38u as=0.38p ps=2.38u w=2u l=0.13u
X283 a_2769_4709# a_2840_5276# VDD VDD sg13_lv_pmos ad=0.38p pd=2.38u as=0.38p ps=2.38u w=2u l=0.13u
X284 VDD VDD VSS rhigh l=0.96u w=0.5u
X285 VDD VDD VSS rhigh l=0.96u w=0.5u
X286 a_2907_6967# a_1267_6967# a_2805_7689# VSS sg13_lv_nmos ad=0.19p pd=1.38u as=0.19p ps=1.38u w=1u l=0.13u
X287 VDD MEM a_4828_5366# VDD sg13_lv_pmos ad=0.68p pd=4.68u as=0.38p ps=2.38u w=2u l=0.13u
X288 VDD a_1479_4709# a_1071_4709# VDD sg13_lv_pmos ad=0.68p pd=4.68u as=0.68p ps=4.68u w=2u l=0.13u
X289 a_3317_5853# a_2907_5853# VDD VDD sg13_lv_pmos ad=0.68p pd=4.68u as=0.68p ps=4.68u w=2u l=0.13u
X290 VDD VDD VSS rhigh l=4u w=0.5u
X291 a_2805_10831# a_1839_10309# VDD VDD sg13_lv_pmos ad=0.38p pd=2.38u as=0.68p ps=4.68u w=2u l=0.13u
X292 a_1941_8081# a_1839_9195# a_1839_8081# VSS sg13_lv_nmos ad=0.19p pd=1.38u as=0.19p ps=1.38u w=1u l=0.13u
X293 a_1839_5853# a_1003_4745# VSS VSS sg13_lv_nmos ad=0.19p pd=1.38u as=0.34p ps=2.68u w=1u l=0.13u
C0 a_4351_8388# a_4351_8176# 0.02952f
C1 a_2907_10309# a_3009_10831# 0.21534f
C2 a_3967_9495# a_3967_9283# 0.02952f
C3 a_4735_9283# VDD 0.02679f
C4 a_2907_8081# a_2907_6967# 0.01112f
C5 a_1267_10309# a_1839_9195# 0.01073f
C6 a_2130_4709# VDD 0.69542f
C7 a_2584_6967# VDD 0.47283f
C8 a_2380_6967# VDD 0.52925f
C9 a_3037_11441# a_3037_11577# 0.29305f
C10 VREF a_1267_9195# 0.03021f
C11 a_1003_4745# a_1267_9195# 0.05713f
C12 VDD a_1941_9195# 0.2285f
C13 a_3521_8081# MEM 0.10901f
C14 a_1003_4745# RST 0.56156f
C15 a_3009_5853# a_2907_5853# 0.09917f
C16 MEM VDD 1.28834f
C17 a_2769_4709# a_2538_4709# 0.13146f
C18 a_2004_11753# a_2004_11577# 0.13024f
C19 a_2004_11753# VDD 0.07976f
C20 a_1820_4745# VDD 0.22534f
C21 a_1918_11577# a_2004_11753# 0.01534f
C22 a_3317_5853# a_2380_5853# 0.0172f
C23 a_1839_5853# a_1941_10831# 0.01749f
C24 a_2584_8081# a_1267_8081# 0.71451f
C25 a_1839_5853# a_917_6931# 0.45472f
C26 a_4351_7482# a_4735_7482# 0.01085f
C27 a_3521_5853# a_3317_5853# 0.40835f
C28 a_4735_7482# a_4735_7694# 0.02952f
C29 a_2805_6375# a_2907_5853# 0.20304f
C30 a_1369_7689# a_1267_6967# 0.09918f
C31 COMP a_3207_4709# 0.21872f
C32 a_2951_11577# a_3984_11577# 0.02622f
C33 a_2805_9917# a_1267_9195# 0.01675f
C34 a_1839_5853# a_2907_5853# 0.01788f
C35 a_5078_11441# VDD 0.04969f
C36 a_3967_8815# VDD 0.03382f
C37 a_3967_7267# a_4351_7267# 0.01085f
C38 a_5078_11753# a_5078_11933# 0.02961f
C39 a_2380_9195# a_1839_5853# 0.02077f
C40 a_1839_9195# a_1941_9195# 0.21287f
C41 a_3967_8603# a_3967_8815# 0.02952f
C42 a_1839_8081# a_1839_6967# 0.2476f
C43 a_4828_5366# MEM 0.46785f
C44 a_2584_6967# a_2805_6967# 0.04511f
C45 a_4351_7267# a_3521_6967# 0.024f
C46 a_1267_5853# a_1267_9195# 0.76752f
C47 a_1267_10309# a_1267_9195# 0.16819f
C48 a_1267_5853# a_3009_6375# 0.02044f
C49 a_5078_11577# a_5078_11441# 0.07033f
C50 a_1839_8081# a_1941_8603# 0.21415f
C51 a_1267_10309# a_1369_9195# 0.01956f
C52 a_3521_10309# VDD 0.78074f
C53 a_3037_11753# a_3037_11577# 0.13024f
C54 a_4351_5948# a_4351_6160# 0.02952f
C55 a_3009_5853# a_2584_5853# 0.04719f
C56 a_3521_10309# a_3317_10309# 0.40835f
C57 a_1839_8081# a_1941_6967# 0.01698f
C58 a_3009_10309# a_2907_10309# 0.0992f
C59 a_2004_11441# a_2004_11577# 0.29305f
C60 a_3009_9917# a_2907_9195# 0.09922f
C61 a_2004_11441# VDD 0.3171f
C62 a_3037_11577# a_2951_11577# 0.05268f
C63 a_2907_6967# a_3009_6967# 0.21534f
C64 a_3009_9917# a_2380_9195# 0.01182f
C65 SPIKE a_1071_4709# 0.12757f
C66 a_2805_6375# a_2584_5853# 0.04511f
C67 a_1839_5853# a_2584_5853# 0.20652f
C68 a_2380_8081# a_3009_8081# 0.01182f
C69 RST a_2130_4709# 0.16603f
C70 a_4351_6160# a_3967_6160# 0.01085f
C71 a_4735_7267# a_4735_7055# 0.02952f
C72 a_1267_9195# a_1941_9195# 0.01706f
C73 a_1839_6967# a_1839_5853# 0.61609f
C74 a_3967_7482# a_3967_7694# 0.02952f
C75 a_4735_11043# VDD 0.03374f
C76 a_2769_4709# a_2840_5276# 0.52069f
C77 VREF a_917_8508# 0.02133f
C78 a_917_8508# a_1003_4745# 0.15036f
C79 a_3037_11933# VDD 0.11493f
C80 a_2380_8081# a_2907_8081# 0.19723f
C81 a_1839_10309# a_1839_5853# 0.24859f
C82 a_1839_8081# a_2584_8081# 0.20243f
C83 a_2804_11753# VDD 0.09859f
C84 a_1820_4745# RST 0.05784f
C85 a_1839_8081# a_1267_8081# 0.8335f
C86 a_1839_9195# a_1941_9917# 0.09921f
C87 a_4351_11043# a_4735_11043# 0.01085f
C88 a_2951_11577# a_4070_11753# 0.02034f
C89 a_3967_8176# a_4351_8176# 0.01085f
C90 a_1267_5853# a_3317_5853# 0.01123f
C91 a_917_8508# a_1369_6375# 0.01186f
C92 a_2538_4709# a_2130_4709# 0.13318f
C93 a_1071_4709# a_1003_4745# 0.41602f
C94 a_4735_10616# a_4735_10831# 0.02872f
C95 COMP a_2380_5853# 0.02344f
C96 a_1839_8081# a_1941_7689# 0.02364f
C97 a_2907_5853# a_2380_5853# 0.19738f
C98 a_3521_8081# a_3521_6967# 0.02864f
C99 VDD a_3521_6967# 0.72163f
C100 a_2907_6967# a_2907_5853# 0.02097f
C101 COMP a_3521_5853# 0.03736f
C102 a_3521_5853# a_2907_5853# 0.01239f
C103 a_1267_6967# VDD 0.82439f
C104 SPIKE COMP 0.51954f
C105 a_1771_11577# a_971_11577# 0.01602f
C106 a_2380_10309# a_2380_9195# 0.03435f
C107 a_917_8508# a_1267_5853# 0.17251f
C108 SPIKE a_1692_4709# 0.24601f
C109 a_917_8508# a_1267_10309# 0.39966f
C110 a_2805_10831# a_2907_10309# 0.20304f
C111 a_3967_6587# VDD 0.03382f
C112 a_971_11753# a_971_11933# 0.12339f
C113 COMP a_2769_4709# 0.14498f
C114 a_971_11577# a_971_11441# 0.29305f
C115 VDD a_2584_9195# 0.47246f
C116 a_1941_6375# a_917_6931# 0.01325f
C117 a_3837_11577# a_3984_11577# 0.17314f
C118 a_2380_10309# a_2907_10309# 0.20088f
C119 a_1771_11577# a_885_11577# 0.02649f
C120 a_2584_8081# a_1839_5853# 0.01989f
C121 a_1267_8081# a_1839_5853# 0.25436f
C122 a_4351_9710# MEM 0.02643f
C123 a_4735_6587# a_4735_6375# 0.02952f
C124 a_1369_10831# VDD 0.23203f
C125 VREF VX 0.12926f
C126 a_1003_4745# VX 6.17095f
C127 COMP a_2897_5460# 0.04778f
C128 a_1369_8603# a_1267_8081# 0.2172f
C129 a_1003_4745# a_917_6931# 0.08895f
C130 VREF a_917_6931# 5.11101f
C131 a_2380_8081# a_3317_8081# 0.0172f
C132 VX a_885_11577# 0.06845f
C133 a_2907_10309# a_2584_10309# 0.3331f
C134 a_4351_7055# a_4735_7055# 0.01085f
C135 a_2584_5853# a_2380_5853# 0.83117f
C136 a_1839_9195# a_2584_9195# 0.20139f
C137 a_3521_8081# VDD 0.72163f
C138 a_2004_11577# VDD 0.07842f
C139 a_1918_11577# a_2004_11577# 0.01534f
C140 a_1918_11577# VDD 0.13803f
C141 VDD a_3009_8603# 0.22744f
C142 a_3037_11753# a_2951_11577# 0.02034f
C143 VDD a_3317_10309# 0.73387f
C144 a_3837_11577# a_3037_11577# 0.01566f
C145 a_4351_7482# a_4351_7694# 0.02952f
C146 a_1839_6967# a_2907_6967# 0.01463f
C147 a_4351_11043# VDD 0.02903f
C148 a_4735_7694# a_4351_7694# 0.01085f
C149 a_4735_11043# a_4735_10831# 0.02952f
C150 a_5078_11577# VDD 0.03071f
C151 a_1839_10309# a_2380_10309# 0.20354f
C152 a_538_11577# VDD 0.03243f
C153 a_538_11753# VDD 0.02928f
C154 a_2805_9195# a_2907_9195# 0.20304f
C155 a_1267_5853# VX 0.15826f
C156 a_2805_8081# a_2907_8081# 0.09917f
C157 a_1267_10309# VX 0.21105f
C158 a_1839_9195# VDD 0.73818f
C159 a_2805_9917# a_2907_9195# 0.09917f
C160 a_1267_10309# a_1941_10831# 0.01376f
C161 a_4828_5366# VDD 0.58678f
C162 a_1267_5853# a_917_6931# 0.11624f
C163 a_1267_10309# a_917_6931# 0.0112f
C164 a_1369_6967# a_1267_6967# 0.22361f
C165 a_1839_6967# a_1941_6375# 0.02756f
C166 a_538_11753# a_538_11577# 0.03126f
C167 a_1839_10309# a_2584_10309# 0.20228f
C168 a_4351_6160# a_4351_6375# 0.02872f
C169 a_1839_10309# a_1941_10309# 0.1072f
C170 a_1267_5853# a_2907_5853# 0.37627f
C171 a_2584_8081# a_2805_8603# 0.04511f
C172 a_4351_6375# a_4735_6375# 0.01085f
C173 a_4070_11441# VDD 0.27655f
C174 a_2805_6967# VDD 0.22722f
C175 a_4351_9710# a_4351_9495# 0.02872f
C176 a_1267_9195# a_2584_9195# 0.70219f
C177 a_4351_8815# a_3967_8815# 0.01085f
C178 a_4070_11933# VDD 0.11522f
C179 a_4735_6587# a_4351_6587# 0.01085f
C180 a_3967_10831# VDD 0.01029f
C181 a_1839_8081# a_1839_5853# 0.03588f
C182 a_4070_11441# a_4351_11043# 0.01084f
C183 a_1839_6967# VREF 0.20506f
C184 a_1839_6967# a_1003_4745# 1.03908f
C185 a_4351_9283# a_3967_9283# 0.01085f
C186 a_1267_10309# a_2907_10309# 0.37961f
C187 VREF a_1839_10309# 0.18656f
C188 a_1839_10309# a_1003_4745# 0.81032f
C189 COMP a_2130_4709# 0.32329f
C190 a_4735_7267# MEM 0.01007f
C191 a_1692_4709# a_2130_4709# 0.0123f
C192 a_4735_8388# a_4351_8388# 0.01085f
C193 a_1267_9195# VDD 0.93792f
C194 a_917_6931# a_1941_9195# 0.01275f
C195 a_4351_10831# MEM 0.0268f
C196 a_3009_6375# VDD 0.22744f
C197 a_1369_6967# VDD 0.22914f
C198 RST VDD 0.49132f
C199 a_3545_4709# VDD 0.52745f
C200 a_1369_9195# VDD 0.22914f
C201 COMP MEM 0.13048f
C202 a_1267_10309# a_1369_10309# 0.10698f
C203 a_538_11933# VDD 0.03032f
C204 a_1267_5853# a_1369_10309# 0.01315f
C205 a_971_11753# a_971_11577# 0.13024f
C206 a_1820_4745# a_1692_4709# 0.1987f
C207 a_1267_5853# a_2584_5853# 0.73923f
C208 a_1839_6967# a_1267_5853# 0.02944f
C209 a_1839_9195# a_1267_9195# 0.57006f
C210 a_971_11753# a_885_11577# 0.02034f
C211 a_538_11753# a_538_11933# 0.02961f
C212 a_3883_4709# VDD 0.52688f
C213 a_1267_10309# a_1839_10309# 0.91449f
C214 a_4351_6375# a_4351_6587# 0.02952f
C215 a_4351_9495# a_3967_9495# 0.01085f
C216 a_2538_4709# VDD 0.47411f
C217 a_2907_8081# VDD 0.18158f
C218 a_3521_8081# a_2907_8081# 0.01239f
C219 a_3037_11753# a_3837_11577# 0.01566f
C220 a_4351_10831# a_3521_10309# 0.024f
C221 a_2907_8081# a_3009_8603# 0.21534f
C222 a_917_8508# a_1267_6967# 0.48204f
C223 a_1267_8081# a_1003_4745# 0.14084f
C224 VREF a_1267_8081# 0.05525f
C225 a_1267_5853# a_2805_5853# 0.017f
C226 a_1839_8081# a_1941_8081# 0.10389f
C227 a_3837_11577# a_2951_11577# 0.02617f
C228 a_4735_9710# a_4735_9495# 0.02872f
C229 a_4735_6160# a_4735_5948# 0.02952f
C230 a_1839_6967# a_2584_6967# 0.20131f
C231 a_4351_6160# a_3521_5853# 0.02437f
C232 SPIKE a_1479_4709# 0.02696f
C233 a_2004_11753# a_2004_11933# 0.12339f
C234 a_1839_6967# a_2380_6967# 0.19576f
C235 a_3009_9195# VDD 0.22744f
C236 VDD a_3317_5853# 0.71679f
C237 a_1267_6967# a_3009_6967# 0.01951f
C238 a_3521_10309# a_2907_10309# 0.01239f
C239 a_1839_10309# a_1941_9195# 0.01707f
C240 a_4735_7267# a_4351_7267# 0.01085f
C241 a_4351_8176# a_4735_8176# 0.01085f
C242 a_3967_6375# a_3967_6160# 0.02872f
C243 a_1369_9195# a_1267_9195# 0.22323f
C244 a_917_8508# VDD 1.32389f
C245 a_1267_5853# a_1267_8081# 0.16116f
C246 a_3545_4709# RST 0.09932f
C247 a_3317_6967# a_2907_6967# 0.14521f
C248 a_2380_8081# a_2584_8081# 0.83154f
C249 a_3967_5948# a_4351_5948# 0.01085f
C250 a_2380_8081# a_1267_8081# 0.59629f
C251 a_4735_10404# a_4351_10404# 0.01085f
C252 a_3009_5853# a_2380_5853# 0.01182f
C253 a_4351_7482# a_3967_7482# 0.01085f
C254 a_4351_8815# VDD 0.02671f
C255 a_1267_6967# VX 0.18113f
C256 a_1071_4709# VDD 0.70016f
C257 a_3317_8081# a_3521_8081# 0.40835f
C258 a_3317_8081# VDD 0.71597f
C259 a_4351_9922# a_4735_9922# 0.01085f
C260 a_4070_11577# VDD 0.07885f
C261 a_3009_6967# VDD 0.22744f
C262 a_3883_4709# a_3545_4709# 0.15149f
C263 a_2584_8081# a_2584_6967# 0.07395f
C264 a_3883_4709# RST 0.10008f
C265 a_1267_6967# a_917_6931# 0.14548f
C266 a_2840_5276# VDD 0.319f
C267 a_3967_5948# a_3967_6160# 0.02952f
C268 a_1839_5853# a_2380_5853# 0.21826f
C269 a_1839_8081# VREF 0.21432f
C270 a_1839_8081# a_1003_4745# 0.74489f
C271 a_2538_4709# RST 0.024f
C272 a_2380_10309# a_1839_5853# 0.01728f
C273 a_1369_5853# a_1003_4745# 0.0153f
C274 a_3521_9195# MEM 0.10901f
C275 a_4351_6375# a_3521_5853# 0.024f
C276 a_538_11441# VDD 0.04915f
C277 SPIKE a_1839_5853# 0.01495f
C278 MEM a_4070_11753# 0.02446f
C279 a_1771_11577# VDD 0.13535f
C280 a_4735_8388# a_4735_8603# 0.02872f
C281 a_1918_11577# a_1771_11577# 0.17736f
C282 a_4351_8603# a_4351_8388# 0.02872f
C283 a_1839_10309# a_1941_9917# 0.02347f
C284 a_3009_10309# a_2380_10309# 0.01182f
C285 a_2951_11577# a_885_11577# 0.10138f
C286 a_3009_8081# a_2907_8081# 0.09917f
C287 a_2584_9195# a_2907_9195# 0.33207f
C288 a_3317_9195# VDD 0.71601f
C289 a_3009_9195# a_1267_9195# 0.01987f
C290 a_971_11441# VDD 0.32149f
C291 a_1941_10309# a_1839_5853# 0.01457f
C292 a_1839_5853# a_2584_10309# 0.01748f
C293 a_2380_9195# a_2584_9195# 0.79681f
C294 a_538_11441# a_538_11577# 0.07033f
C295 a_2805_10309# a_2907_10309# 0.09917f
C296 a_1941_6375# a_1839_5853# 0.2177f
C297 a_1267_10309# a_3009_10831# 0.02044f
C298 a_3317_9195# a_3317_10309# 0.03047f
C299 VX VDD 1.06252f
C300 a_1941_10831# VDD 0.23221f
C301 a_4351_10616# MEM 0.02625f
C302 a_3009_10309# a_2584_10309# 0.04714f
C303 a_4070_11441# a_4070_11577# 0.29305f
C304 VDD a_917_6931# 1.25687f
C305 a_4351_7055# a_4351_7267# 0.02952f
C306 a_917_8508# a_1267_9195# 0.62303f
C307 a_1267_5853# a_1369_5853# 0.09917f
C308 a_3967_7055# a_3967_7267# 0.02952f
C309 a_4351_10616# a_4735_10616# 0.01085f
C310 COMP VDD 0.9419f
C311 a_917_8508# a_1369_6967# 0.01344f
C312 a_3521_9195# a_3521_10309# 0.02864f
C313 a_3967_10616# a_3967_10404# 0.02952f
C314 VDD a_2907_5853# 0.18145f
C315 a_1692_4709# VDD 0.13854f
C316 a_917_8508# a_1369_9195# 0.01353f
C317 a_538_11577# VX 0.0101f
C318 a_3967_10404# a_4351_10404# 0.01085f
C319 VDD a_2907_9195# 0.18205f
C320 a_1839_8081# a_2380_8081# 0.20529f
C321 VREF a_1839_5853# 4.42108f
C322 a_1839_5853# a_1003_4745# 0.24582f
C323 a_4351_11043# a_4351_10831# 0.02952f
C324 a_1369_8081# a_1267_9195# 0.01603f
C325 a_2380_9195# VDD 0.52955f
C326 a_5078_11933# VDD 0.02843f
C327 a_2907_6967# a_2805_7689# 0.09917f
C328 a_1839_6967# a_1267_6967# 0.86515f
C329 a_1369_7689# a_1267_8081# 0.02351f
C330 MEM a_4351_6160# 0.02635f
C331 a_3521_9195# a_4351_9495# 0.024f
C332 a_1839_9195# a_917_6931# 0.669f
C333 a_1267_10309# a_1369_9917# 0.02342f
C334 a_2907_10309# VDD 0.21248f
C335 a_1071_4709# RST 0.09224f
C336 a_4221_4709# VDD 0.52878f
C337 a_2805_8081# a_2584_8081# 0.01463f
C338 a_4828_5366# COMP 0.42881f
C339 a_2907_10309# a_3317_10309# 0.14521f
C340 a_2805_8081# a_1267_8081# 0.01675f
C341 a_4351_10616# a_3521_10309# 0.02437f
C342 a_1839_9195# a_2907_9195# 0.01489f
C343 a_2840_5276# RST 0.05759f
C344 a_4351_9283# a_4735_9283# 0.01085f
C345 a_1839_9195# a_2380_9195# 0.19537f
C346 a_1267_6967# a_1941_6967# 0.01432f
C347 a_3967_6375# a_4351_6375# 0.01085f
C348 a_2951_11577# MEM 0.0732f
C349 a_3984_11577# VDD 0.13535f
C350 a_2380_6967# a_3317_6967# 0.0172f
C351 a_1267_5853# a_1839_5853# 0.96879f
C352 a_1267_10309# a_1839_5853# 0.09012f
C353 a_2004_11933# VDD 0.1151f
C354 a_4351_10831# a_3967_10831# 0.01085f
C355 a_2584_5853# VDD 0.47437f
C356 a_3317_9195# a_1267_9195# 0.01067f
C357 a_3967_7055# VDD 0.03382f
C358 a_2380_8081# a_1839_5853# 0.02197f
C359 a_1839_6967# VDD 0.72575f
C360 VX a_1267_9195# 0.19267f
C361 a_3317_8081# a_2907_8081# 0.14521f
C362 a_2805_10831# a_2584_10309# 0.04511f
C363 a_1839_10309# VDD 0.73289f
C364 a_2840_5276# a_2538_4709# 0.02801f
C365 a_1267_9195# a_917_6931# 0.0289f
C366 a_4351_7055# VDD 0.02671f
C367 a_2380_10309# a_2584_10309# 0.77156f
C368 a_1941_8603# VDD 0.22836f
C369 a_2584_6967# a_1839_5853# 0.02221f
C370 a_3967_10616# a_3967_10831# 0.02872f
C371 a_1267_8081# a_1267_6967# 0.229f
C372 a_2380_6967# a_1839_5853# 0.02132f
C373 a_3009_6375# a_2907_5853# 0.21534f
C374 COMP a_3545_4709# 0.2067f
C375 COMP RST 0.37376f
C376 a_1267_9195# a_2907_9195# 0.37517f
C377 a_4351_9922# a_3967_9922# 0.01085f
C378 a_4735_9495# a_4735_9283# 0.02952f
C379 a_3037_11577# VDD 0.07827f
C380 a_1941_6967# VDD 0.2285f
C381 MEM a_4351_8603# 0.02671f
C382 a_1692_4709# RST 0.27747f
C383 a_2380_9195# a_1267_9195# 0.63385f
C384 a_4351_10831# a_4735_10831# 0.01085f
C385 MEM a_4351_6375# 0.02594f
C386 a_971_11753# VDD 0.08357f
C387 a_4351_9922# a_4351_9710# 0.02952f
C388 a_1839_10309# a_1839_9195# 0.23596f
C389 MEM a_4735_9495# 0.01016f
C390 a_4351_8603# a_4735_8603# 0.01085f
C391 a_1839_9195# a_1941_8603# 0.02669f
C392 VREF SPIKE 0.02311f
C393 SPIKE a_1003_4745# 0.21681f
C394 a_2769_4709# a_2897_5460# 0.09977f
C395 COMP a_3883_4709# 0.20413f
C396 a_4221_4709# RST 0.10042f
C397 a_3037_11933# a_3037_11753# 0.12339f
C398 a_4351_9495# a_4351_9283# 0.02952f
C399 a_3521_9195# a_3521_8081# 0.03716f
C400 COMP a_2538_4709# 0.04697f
C401 a_3521_9195# VDD 0.72163f
C402 a_3037_11753# a_2804_11753# 0.01498f
C403 a_2584_8081# VDD 0.4728f
C404 a_4735_8815# a_4735_8603# 0.02952f
C405 a_2907_8081# a_2907_9195# 0.02097f
C406 a_1267_8081# VDD 0.78872f
C407 VDD a_4070_11753# 0.07993f
C408 a_1267_8081# a_3009_8603# 0.02006f
C409 a_4351_7482# MEM 0.02651f
C410 a_2951_11577# a_2804_11753# 0.03813f
C411 a_1267_5853# a_2380_5853# 0.60641f
C412 a_4221_4709# a_3883_4709# 0.15167f
C413 a_2584_6967# a_2805_7689# 0.01463f
C414 a_1267_10309# a_2380_10309# 0.63065f
C415 a_3037_11441# VDD 0.31526f
C416 COMP a_3317_5853# 0.02406f
C417 a_3317_5853# a_2907_5853# 0.14521f
C418 a_3009_9195# a_2907_9195# 0.21534f
C419 a_917_8508# VX 4.07577f
C420 a_1839_9195# a_1267_8081# 0.03204f
C421 VREF a_1003_4745# 0.45807f
C422 a_971_11577# a_885_11577# 0.05224f
C423 a_4351_6160# a_4735_6160# 0.01085f
C424 a_4735_6160# a_4735_6375# 0.02872f
C425 a_917_8508# a_917_6931# 0.04203f
C426 a_1267_6967# a_1369_5853# 0.01488f
C427 a_1839_6967# a_1941_5853# 0.01612f
C428 a_4351_9495# a_4735_9495# 0.01085f
C429 a_1267_10309# a_2584_10309# 0.678f
C430 a_3317_8081# a_3317_9195# 0.01806f
C431 a_3317_6967# a_3521_6967# 0.40835f
C432 a_1267_5853# a_1941_6375# 0.01275f
C433 a_4351_8388# a_3967_8388# 0.01085f
C434 a_4735_8388# a_4735_8176# 0.02952f
C435 a_3317_6967# a_1267_6967# 0.01031f
C436 a_4070_11933# a_4070_11753# 0.12339f
C437 a_2584_6967# a_2907_6967# 0.34325f
C438 a_2380_6967# a_2907_6967# 0.19723f
C439 SPIKE a_2130_4709# 0.26706f
C440 a_1479_4709# VDD 0.51026f
C441 a_3009_10831# VDD 0.23147f
C442 a_4735_7267# a_4735_7482# 0.02872f
C443 MEM a_3521_5853# 0.10883f
C444 VREF a_1267_5853# 0.0768f
C445 a_1267_5853# a_1003_4745# 4.37305f
C446 VREF a_1267_10309# 0.01098f
C447 a_1267_10309# a_1003_4745# 0.11201f
C448 a_4735_6587# VDD 0.02679f
C449 a_538_11441# VX 0.01147f
C450 a_3037_11753# VDD 0.07935f
C451 COMP a_2840_5276# 0.40363f
C452 a_1839_8081# VDD 0.72337f
C453 MEM a_4351_8388# 0.02643f
C454 a_1267_8081# a_1267_9195# 0.47286f
C455 a_1369_6967# a_1267_8081# 0.01878f
C456 a_2951_11577# VDD 1.52304f
C457 a_1267_6967# a_1839_5853# 0.36249f
C458 a_4351_7482# a_4351_7267# 0.02872f
C459 a_4351_9283# VDD 0.02671f
C460 a_1267_5853# a_1369_6375# 0.21646f
C461 a_3317_6967# VDD 0.71597f
C462 a_3967_6587# a_4351_6587# 0.01085f
C463 a_1839_5853# a_2584_9195# 0.02017f
C464 a_3967_9922# a_3967_9710# 0.02952f
C465 a_2584_8081# a_3009_8081# 0.04719f
C466 VX a_917_6931# 0.02072f
C467 a_3317_9195# a_2907_9195# 0.14521f
C468 a_1839_8081# a_1839_9195# 0.29007f
C469 a_3967_7482# a_3967_7267# 0.02872f
C470 a_2380_9195# a_3317_9195# 0.0172f
C471 a_1267_10309# a_1267_5853# 0.33245f
C472 a_4351_9710# a_3967_9710# 0.01085f
C473 a_917_8508# a_1839_10309# 0.03192f
C474 a_2584_8081# a_2907_8081# 0.34325f
C475 a_4351_7482# a_3521_6967# 0.02437f
C476 a_4070_11577# a_3984_11577# 0.01578f
C477 a_2907_8081# a_1267_8081# 0.37587f
C478 a_2805_6375# VDD 0.22722f
C479 a_5078_11753# VDD 0.02783f
C480 a_3521_8081# a_4351_8603# 0.024f
C481 COMP a_2907_5853# 0.01039f
C482 a_2004_11753# a_885_11577# 0.02034f
C483 VDD a_3967_9283# 0.03382f
C484 COMP a_1692_4709# 0.44996f
C485 a_3207_4709# VDD 0.52782f
C486 a_3967_8603# a_4351_8603# 0.01085f
C487 a_1839_5853# VDD 0.91502f
C488 VDD a_4351_6587# 0.02671f
C489 a_3009_9917# a_2584_9195# 0.04702f
C490 a_4351_5948# a_4735_5948# 0.01085f
C491 a_4735_9922# a_4735_9710# 0.02952f
C492 a_2380_9195# a_2907_9195# 0.20077f
C493 a_5078_11577# a_5078_11753# 0.03126f
C494 a_3521_9195# a_4351_9710# 0.02437f
C495 a_1479_4709# RST 0.03868f
C496 a_971_11933# VDD 0.11735f
C497 a_4735_8815# VDD 0.02679f
C498 a_1369_8603# VDD 0.22876f
C499 a_1267_6967# a_2805_7689# 0.01675f
C500 COMP a_4221_4709# 0.35342f
C501 a_2907_10309# a_2907_9195# 0.01112f
C502 a_2380_8081# a_2380_6967# 0.03435f
C503 a_1839_8081# a_1267_9195# 0.01817f
C504 a_1839_9195# a_1839_5853# 0.03493f
C505 a_917_8508# a_1267_8081# 0.52305f
C506 a_3967_8176# a_3967_8388# 0.02952f
C507 a_2907_6967# a_3521_6967# 0.01239f
C508 COMP a_2584_5853# 0.04263f
C509 a_3009_7689# a_2907_6967# 0.09917f
C510 a_2380_6967# a_2584_6967# 0.83154f
C511 a_2584_5853# a_2907_5853# 0.3427f
C512 a_3521_5853# a_3521_6967# 0.03716f
C513 a_1267_8081# a_1369_8081# 0.1037f
C514 a_1839_6967# a_917_6931# 0.68693f
C515 a_3967_9710# a_3967_9495# 0.02872f
C516 a_3967_11043# VDD 0.04017f
C517 a_2907_6967# a_1267_6967# 0.37474f
C518 a_1839_10309# a_1941_10831# 0.20989f
C519 a_1369_9917# a_1267_9195# 0.09919f
C520 a_971_11753# a_1771_11577# 0.01602f
C521 a_1839_10309# a_917_6931# 0.50569f
C522 a_3317_8081# a_1267_8081# 0.01086f
C523 a_1941_8603# a_917_6931# 0.01258f
C524 a_1839_8081# a_2907_8081# 0.01582f
C525 a_3967_11043# a_4351_11043# 0.01085f
C526 a_4070_11577# a_4070_11753# 0.13024f
C527 a_2805_8603# VDD 0.22722f
C528 a_3837_11577# VDD 0.13595f
C529 a_4735_7055# VDD 0.02679f
C530 a_1941_6967# a_917_6931# 0.0153f
C531 a_971_11753# VX 0.02483f
C532 a_2805_10309# a_2584_10309# 0.01463f
C533 a_1839_5853# a_1267_9195# 0.39656f
C534 a_2804_11753# a_885_11577# 0.0384f
C535 a_3207_4709# a_3545_4709# 0.15107f
C536 a_3207_4709# RST 0.10055f
C537 a_2805_5853# a_2907_5853# 0.09917f
C538 a_2805_10831# VDD 0.23228f
C539 MEM a_4735_8603# 0.01016f
C540 a_1839_10309# a_2907_10309# 0.01075f
C541 a_2584_10309# a_2584_9195# 0.07395f
C542 a_3521_9195# a_3317_9195# 0.40835f
C543 MEM a_5078_11441# 0.01073f
C544 VDD a_2380_5853# 0.53091f
C545 a_1369_8603# a_1267_9195# 0.03168f
C546 a_2380_10309# VDD 0.53238f
C547 a_2907_6967# VDD 0.18194f
C548 a_3521_5853# VDD 0.72163f
C549 a_1941_5853# a_1839_5853# 0.10077f
C550 SPIKE VDD 0.69674f
C551 VREF a_1267_6967# 0.04577f
C552 a_2380_10309# a_3317_10309# 0.0172f
C553 a_1267_6967# a_1003_4745# 0.06917f
C554 a_1267_8081# VX 0.19947f
C555 a_1839_9195# a_1941_8081# 0.01613f
C556 a_3967_11043# a_3967_10831# 0.02952f
C557 a_3521_8081# a_4351_8388# 0.02437f
C558 a_3317_6967# a_3317_5853# 0.01806f
C559 MEM a_3521_10309# 0.10902f
C560 a_1267_8081# a_917_6931# 0.02941f
C561 a_2769_4709# VDD 0.59703f
C562 VDD a_2584_10309# 0.48433f
C563 a_1071_4709# a_1479_4709# 0.14353f
C564 a_3521_9195# a_2907_9195# 0.01239f
C565 a_1941_6375# VDD 0.22837f
C566 a_3967_7055# a_4351_7055# 0.01085f
C567 a_1267_6967# a_1369_6375# 0.03293f
C568 a_4351_9495# MEM 0.02671f
C569 a_2805_5853# a_2584_5853# 0.01463f
C570 a_2805_9195# a_2584_9195# 0.04511f
C571 a_971_11577# VDD 0.08025f
C572 a_4735_10404# a_4735_10616# 0.02952f
C573 a_3967_7694# a_4351_7694# 0.01085f
C574 a_2805_9917# a_2584_9195# 0.01463f
C575 a_4351_10616# a_4351_10831# 0.02872f
C576 a_2907_6967# a_2805_6967# 0.20304f
C577 a_1267_5853# a_1267_6967# 0.6024f
C578 a_1839_6967# a_1941_6967# 0.20989f
C579 a_3967_6587# a_3967_6375# 0.02952f
C580 a_1003_4745# VDD 1.26947f
C581 a_1267_10309# a_2805_10309# 0.01675f
C582 VREF VDD 0.22292f
C583 a_4070_11577# a_2951_11577# 0.05255f
C584 MEM a_4351_7267# 0.02664f
C585 a_2004_11577# a_885_11577# 0.05294f
C586 VDD a_885_11577# 1.47487f
C587 a_3317_8081# a_3317_6967# 0.03047f
C588 a_1918_11577# a_885_11577# 0.02597f
C589 a_2004_11753# a_2804_11753# 0.01525f
C590 a_4735_9710# a_4351_9710# 0.01085f
C591 a_2805_9195# VDD 0.22722f
C592 a_3984_11577# a_4070_11753# 0.01578f
C593 VDD a_1369_6375# 0.22876f
C594 a_2584_6967# a_3009_7689# 0.04719f
C595 a_2380_6967# a_3009_7689# 0.01182f
C596 a_1267_5853# a_1369_10831# 0.01681f
C597 a_3967_10616# a_4351_10616# 0.01085f
C598 a_1267_10309# a_1369_10831# 0.21767f
C599 a_4351_10616# a_4351_10404# 0.02952f
C600 a_2584_6967# a_1267_6967# 0.71176f
C601 COMP a_1479_4709# 0.03361f
C602 VREF a_1839_9195# 0.17487f
C603 a_1839_9195# a_1003_4745# 1.10729f
C604 a_2380_6967# a_1267_6967# 0.624f
C605 a_1479_4709# a_1692_4709# 0.13829f
C606 MEM a_3521_6967# 0.10899f
C607 a_4351_8815# a_4351_8603# 0.02952f
C608 a_917_8508# a_1369_8603# 0.01479f
C609 a_1839_6967# a_1267_8081# 0.01066f
C610 SPIKE RST 0.15213f
C611 a_1267_5853# VDD 0.97838f
C612 a_1267_10309# VDD 0.91033f
C613 a_2805_8603# a_2907_8081# 0.20304f
C614 a_1839_8081# a_917_6931# 0.46393f
C615 a_1267_8081# a_1941_8603# 0.01308f
C616 a_1267_10309# a_3317_10309# 0.01121f
C617 a_2840_5276# a_3207_4709# 0.12877f
C618 a_2769_4709# RST 0.33204f
C619 a_2380_8081# VDD 0.52925f
C620 a_4735_8815# a_4351_8815# 0.01085f
C621 a_1839_6967# a_1941_7689# 0.09918f
C622 a_3967_8603# a_3967_8388# 0.02872f
C623 SPIKE VSS 0.96242f
C624 RST VSS 0.725f
C625 COMP VSS 1.55428f
C626 VREF VSS 1.51515f
C627 MEM VSS 8.51022f
C628 VX VSS 2.49206f
C629 VDD VSS 28.8285f
C630 a_1820_4745# VSS 0.01178f
C631 a_2897_5460# VSS 0.13184f
C632 a_4828_5366# VSS 0.71772f
C633 a_4221_4709# VSS 0.58232f
C634 a_3883_4709# VSS 0.5763f
C635 a_3545_4709# VSS 0.57098f
C636 a_3207_4709# VSS 0.56799f
C637 a_2840_5276# VSS 0.26643f
C638 a_2769_4709# VSS 0.22808f
C639 a_2538_4709# VSS 0.4825f
C640 a_2130_4709# VSS 0.70476f
C641 a_1692_4709# VSS 0.44378f
C642 a_1479_4709# VSS 0.48707f
C643 a_1071_4709# VSS 0.74286f
C644 a_4735_5948# VSS 0.23931f $ **FLOATING
C645 a_4351_5948# VSS 0.21679f $ **FLOATING
C646 a_3967_5948# VSS 0.23197f $ **FLOATING
C647 a_3009_5853# VSS 0.1325f
C648 a_2805_5853# VSS 0.1338f
C649 a_1941_5853# VSS 0.13359f
C650 a_1369_5853# VSS 0.13359f
C651 a_4735_6160# VSS 0.20073f $ **FLOATING
C652 a_4351_6160# VSS 0.1346f $ **FLOATING
C653 a_3967_6160# VSS 0.19389f $ **FLOATING
C654 a_4735_6375# VSS 0.19981f $ **FLOATING
C655 a_4351_6375# VSS 0.1342f $ **FLOATING
C656 a_3967_6375# VSS 0.18585f $ **FLOATING
C657 a_4735_6587# VSS 0.19918f $ **FLOATING
C658 a_4351_6587# VSS 0.18521f $ **FLOATING
C659 a_3967_6587# VSS 0.18517f $ **FLOATING
C660 a_3521_5853# VSS 0.99181f
C661 a_3009_6375# VSS 0.01316f
C662 a_2805_6375# VSS 0.01208f
C663 a_1941_6375# VSS 0.01246f
C664 a_1369_6375# VSS 0.0124f
C665 a_3317_5853# VSS 0.74791f
C666 a_2907_5853# VSS 0.30669f
C667 a_2380_5853# VSS 0.55066f
C668 a_2584_5853# VSS 0.49445f
C669 a_4735_7055# VSS 0.19918f $ **FLOATING
C670 a_4351_7055# VSS 0.18521f $ **FLOATING
C671 a_3967_7055# VSS 0.18517f $ **FLOATING
C672 a_4735_7267# VSS 0.19981f $ **FLOATING
C673 a_4351_7267# VSS 0.1342f $ **FLOATING
C674 a_3967_7267# VSS 0.18585f $ **FLOATING
C675 a_3009_6967# VSS 0.01316f
C676 a_2805_6967# VSS 0.01208f
C677 a_1941_6967# VSS 0.01249f
C678 a_1369_6967# VSS 0.01243f
C679 a_4735_7482# VSS 0.20073f $ **FLOATING
C680 a_4351_7482# VSS 0.1346f $ **FLOATING
C681 a_3967_7482# VSS 0.19389f $ **FLOATING
C682 a_4735_7694# VSS 0.23556f $ **FLOATING
C683 a_4351_7694# VSS 0.21203f $ **FLOATING
C684 a_3967_7694# VSS 0.22877f $ **FLOATING
C685 a_3521_6967# VSS 1.00151f
C686 a_3009_7689# VSS 0.1325f
C687 a_2805_7689# VSS 0.1338f
C688 a_1941_7689# VSS 0.13359f
C689 a_1369_7689# VSS 0.13359f
C690 a_3317_6967# VSS 0.74542f
C691 a_2907_6967# VSS 0.31189f
C692 a_2380_6967# VSS 0.5423f
C693 a_2584_6967# VSS 0.48231f
C694 a_1267_6967# VSS 0.87121f
C695 a_1839_6967# VSS 0.8089f
C696 a_4735_8176# VSS 0.23556f $ **FLOATING
C697 a_4351_8176# VSS 0.21203f $ **FLOATING
C698 a_3967_8176# VSS 0.22877f $ **FLOATING
C699 a_3009_8081# VSS 0.1325f
C700 a_2805_8081# VSS 0.1338f
C701 a_1941_8081# VSS 0.13359f
C702 a_1369_8081# VSS 0.13359f
C703 a_4735_8388# VSS 0.20073f $ **FLOATING
C704 a_4351_8388# VSS 0.1346f $ **FLOATING
C705 a_3967_8388# VSS 0.19389f $ **FLOATING
C706 a_4735_8603# VSS 0.19981f $ **FLOATING
C707 a_4351_8603# VSS 0.1342f $ **FLOATING
C708 a_3967_8603# VSS 0.18585f $ **FLOATING
C709 a_4735_8815# VSS 0.19918f $ **FLOATING
C710 a_4351_8815# VSS 0.18521f $ **FLOATING
C711 a_3967_8815# VSS 0.18517f $ **FLOATING
C712 a_3521_8081# VSS 1.00151f
C713 a_3009_8603# VSS 0.01316f
C714 a_2805_8603# VSS 0.01208f
C715 a_1941_8603# VSS 0.01246f
C716 a_1369_8603# VSS 0.01232f
C717 a_3317_8081# VSS 0.74537f
C718 a_2907_8081# VSS 0.31138f
C719 a_2380_8081# VSS 0.54217f
C720 a_2584_8081# VSS 0.48222f
C721 a_1267_8081# VSS 0.85547f
C722 a_1839_8081# VSS 0.80727f
C723 a_4735_9283# VSS 0.19918f $ **FLOATING
C724 a_4351_9283# VSS 0.18521f $ **FLOATING
C725 a_3967_9283# VSS 0.18517f $ **FLOATING
C726 a_4735_9495# VSS 0.19981f $ **FLOATING
C727 a_4351_9495# VSS 0.1342f $ **FLOATING
C728 a_3967_9495# VSS 0.18585f $ **FLOATING
C729 a_3009_9195# VSS 0.01316f
C730 a_2805_9195# VSS 0.01208f
C731 a_1941_9195# VSS 0.01249f
C732 a_1369_9195# VSS 0.01249f
C733 a_4735_9710# VSS 0.20073f $ **FLOATING
C734 a_4351_9710# VSS 0.1346f $ **FLOATING
C735 a_3967_9710# VSS 0.19389f $ **FLOATING
C736 a_4735_9922# VSS 0.23556f $ **FLOATING
C737 a_4351_9922# VSS 0.21203f $ **FLOATING
C738 a_3967_9922# VSS 0.22877f $ **FLOATING
C739 a_3521_9195# VSS 1.00151f
C740 a_3009_9917# VSS 0.1325f
C741 a_2805_9917# VSS 0.1338f
C742 a_1941_9917# VSS 0.13359f
C743 a_1369_9917# VSS 0.13359f
C744 a_3317_9195# VSS 0.74541f
C745 a_2907_9195# VSS 0.31289f
C746 a_2380_9195# VSS 0.54332f
C747 a_2584_9195# VSS 0.48199f
C748 a_1267_9195# VSS 0.89411f
C749 a_1839_9195# VSS 0.80147f
C750 a_4735_10404# VSS 0.23556f $ **FLOATING
C751 a_4351_10404# VSS 0.21203f $ **FLOATING
C752 a_3967_10404# VSS 0.22877f $ **FLOATING
C753 a_3009_10309# VSS 0.1325f
C754 a_2805_10309# VSS 0.1338f
C755 a_1941_10309# VSS 0.13359f
C756 a_1369_10309# VSS 0.13359f
C757 a_4735_10616# VSS 0.20073f $ **FLOATING
C758 a_4351_10616# VSS 0.1346f $ **FLOATING
C759 a_3967_10616# VSS 0.19389f $ **FLOATING
C760 a_1003_4745# VSS 3.0472f
C761 a_4735_10831# VSS 0.19981f $ **FLOATING
C762 a_4351_10831# VSS 0.1342f $ **FLOATING
C763 a_3967_10831# VSS 0.18585f $ **FLOATING
C764 a_4735_11043# VSS 0.19854f $ **FLOATING
C765 a_4351_11043# VSS 0.1827f $ **FLOATING
C766 a_3967_11043# VSS 0.18354f $ **FLOATING
C767 a_3521_10309# VSS 0.99077f
C768 a_3009_10831# VSS 0.01316f
C769 a_2805_10831# VSS 0.01208f
C770 a_1941_10831# VSS 0.01249f
C771 a_1369_10831# VSS 0.01249f
C772 a_3317_10309# VSS 0.74489f
C773 a_2907_10309# VSS 0.31479f
C774 a_2380_10309# VSS 0.54586f
C775 a_2584_10309# VSS 0.48478f
C776 a_1267_10309# VSS 0.9375f
C777 a_1839_10309# VSS 0.84062f
C778 a_917_6931# VSS 0.72076f
C779 a_1839_5853# VSS 1.07345f
C780 a_917_8508# VSS 0.63108f
C781 a_1267_5853# VSS 0.97107f
C782 a_5078_11441# VSS 0.09313f $ **FLOATING
C783 a_4070_11441# VSS 0.27931f $ **FLOATING
C784 a_3037_11441# VSS 0.2551f $ **FLOATING
C785 a_2004_11441# VSS 0.25727f $ **FLOATING
C786 a_971_11441# VSS 0.25747f $ **FLOATING
C787 a_538_11441# VSS 0.09313f $ **FLOATING
C788 a_5078_11577# VSS 0.06842f $ **FLOATING
C789 a_4070_11577# VSS 0.27767f $ **FLOATING
C790 a_3037_11577# VSS 0.27625f $ **FLOATING
C791 a_2951_11577# VSS 0.16205f
C792 a_2004_11577# VSS 0.27596f $ **FLOATING
C793 a_971_11577# VSS 0.27596f $ **FLOATING
C794 a_885_11577# VSS 0.16176f
C795 a_538_11577# VSS 0.06623f $ **FLOATING
C796 a_5078_11753# VSS 0.07669f $ **FLOATING
C797 a_4070_11753# VSS 0.31466f $ **FLOATING
C798 a_3984_11577# VSS 0.10032f
C799 a_3837_11577# VSS 0.10012f
C800 a_3037_11753# VSS 0.31129f $ **FLOATING
C801 a_2804_11753# VSS 0.11313f
C802 a_2004_11753# VSS 0.3106f $ **FLOATING
C803 a_1918_11577# VSS 0.09917f
C804 a_1771_11577# VSS 0.10043f
C805 a_971_11753# VSS 0.3106f $ **FLOATING
C806 a_538_11753# VSS 0.07454f $ **FLOATING
C807 a_5078_11933# VSS 0.10359f $ **FLOATING
C808 a_4070_11933# VSS 0.42468f $ **FLOATING
C809 a_3037_11933# VSS 0.42264f $ **FLOATING
C810 a_2004_11933# VSS 0.42223f $ **FLOATING
C811 a_971_11933# VSS 0.42223f $ **FLOATING
C812 a_538_11933# VSS 0.10134f $ **FLOATING
.ends
