*********************************************************
*** NGSPICE file created by KLayout-PEX 0.3.7
*** -----------------------------------------------------
***     Extraction Engine: KPEX/2.5D
***     Technology: ihp_sg13g2
***     Date: 2026-03-05 17:58:49
*********************************************************
.SUBCKT LIF_neuron VDD Vx MEM RST SPIKE VSS Vref
xM$1 VSS \$6 \$5 VSS sg13_lv_nmos L=0.13U W=1U AS=0.34P AD=0.19P PS=2.68U
+ PD=1.38U
xM$2 \$43 \$9 VSS VSS sg13_lv_nmos L=0.13U W=1U AS=0.19P AD=0.19P PS=1.38U
+ PD=1.38U
xM$3 \$6 Vout|vCMP \$43 VSS sg13_lv_nmos L=0.13U W=1U AS=0.19P AD=0.34P PS=1.38U
+ PD=2.68U
xM$4 VSS \$10 \$9 VSS sg13_lv_nmos L=0.65U W=1U AS=0.34P AD=0.34P PS=2.68U
+ PD=2.68U
xM$5 VSS \$11 \$10 VSS sg13_lv_nmos L=0.65U W=1U AS=0.34P AD=0.34P PS=2.68U
+ PD=2.68U
xM$6 VSS \$12 \$11 VSS sg13_lv_nmos L=0.65U W=1U AS=0.34P AD=0.34P PS=2.68U
+ PD=2.68U
xM$7 VSS \$13 \$12 VSS sg13_lv_nmos L=0.65U W=1U AS=0.34P AD=0.34P PS=2.68U
+ PD=2.68U
xM$8 VSS Vout|vCMP \$13 VSS sg13_lv_nmos L=0.65U W=1U AS=0.34P AD=0.34P PS=2.68U
+ PD=2.68U
xM$9 VSS \$7 RST VSS sg13_lv_nmos L=0.13U W=1U AS=0.34P AD=0.19P PS=2.68U
+ PD=1.38U
xM$10 RST \$7 VSS VSS sg13_lv_nmos L=0.13U W=1U AS=0.19P AD=0.19P PS=1.38U
+ PD=1.38U
xM$11 VSS \$7 RST VSS sg13_lv_nmos L=0.13U W=1U AS=0.19P AD=0.34P PS=1.38U
+ PD=2.68U
xM$12 VSS \$8 \$7 VSS sg13_lv_nmos L=0.13U W=1U AS=0.34P AD=0.34P PS=2.68U
+ PD=2.68U
xM$13 VSS \$39 \$8 VSS sg13_lv_nmos L=0.13U W=1U AS=0.34P AD=0.19P PS=2.68U
+ PD=1.38U
xM$14 \$39 Vout|vCMP VSS VSS sg13_lv_nmos L=0.13U W=1U AS=0.19P AD=0.19P
+ PS=1.38U PD=1.38U
xM$15 VSS RST|Ven \$39 VSS sg13_lv_nmos L=0.13U W=1U AS=0.19P AD=0.34P PS=1.38U
+ PD=2.68U
xM$16 VSS \$40 SPIKE VSS sg13_lv_nmos L=0.13U W=1U AS=0.34P AD=0.19P
+ PS=2.68U PD=1.38U
xM$17 SPIKE \$40 VSS VSS sg13_lv_nmos L=0.13U W=1U AS=0.19P AD=0.19P
+ PS=1.38U PD=1.38U
xM$18 VSS \$40 SPIKE VSS sg13_lv_nmos L=0.13U W=1U AS=0.19P AD=0.34P
+ PS=1.38U PD=2.68U
xM$19 VSS \$5 \$40 VSS sg13_lv_nmos L=0.13U W=1U AS=0.34P AD=0.34P PS=2.68U
+ PD=2.68U
xM$20 Vout|vCMP \$14 VSS VSS sg13_lv_nmos L=0.13U W=1U AS=0.34P AD=0.19P
+ PS=2.68U PD=1.38U
xM$21 VSS \$14 Vout|vCMP VSS sg13_lv_nmos L=0.13U W=1U AS=0.19P AD=0.19P
+ PS=1.38U PD=1.38U
xM$22 \$14 VOUT|Vin VSS VSS sg13_lv_nmos L=0.13U W=1U AS=0.19P AD=0.19P PS=1.38U
+ PD=1.38U
xM$23 VSS VOUT|Vin \$14 VSS sg13_lv_nmos L=0.13U W=1U AS=0.19P AD=0.34P PS=1.38U
+ PD=2.68U
xM$24 \$136 Vref VSS VSS sg13_lv_nmos L=0.13U W=1U AS=0.34P AD=0.34P PS=2.68U
+ PD=2.68U
xM$25 \$130 VSS VSS VSS sg13_lv_nmos L=0.13U W=1U AS=0.34P AD=0.19P PS=2.68U
+ PD=1.38U
xM$26 \$166 \$164 \$130 VSS sg13_lv_nmos L=0.13U W=1U AS=0.19P AD=0.19P PS=1.38U
+ PD=1.38U
xM$27 VSS Vctr|Vx \$166 VSS sg13_lv_nmos L=0.13U W=1U AS=0.19P AD=0.34P PS=1.38U
+ PD=2.68U
xM$28 \$71 RST VSS VSS sg13_lv_nmos L=0.13U W=1U AS=0.34P AD=0.19P PS=2.68U
+ PD=1.38U
xM$29 \$45 \$130 \$71 VSS sg13_lv_nmos L=0.13U W=1U AS=0.19P AD=0.19P PS=1.38U
+ PD=1.38U
xM$30 VSS Vctr|Vx \$45 VSS sg13_lv_nmos L=0.13U W=1U AS=0.19P AD=0.34P PS=1.38U
+ PD=2.68U
xM$31 \$100 VSS VSS VSS sg13_lv_nmos L=0.13U W=1U AS=0.34P AD=0.19P PS=2.68U
+ PD=1.38U
xM$32 \$172 \$165 \$100 VSS sg13_lv_nmos L=0.13U W=1U AS=0.19P AD=0.19P PS=1.38U
+ PD=1.38U
xM$33 VSS Vref \$172 VSS sg13_lv_nmos L=0.13U W=1U AS=0.19P AD=0.34P PS=1.38U
+ PD=2.68U
xM$34 \$46 RST VSS VSS sg13_lv_nmos L=0.13U W=1U AS=0.34P AD=0.19P PS=2.68U
+ PD=1.38U
xM$35 \$72 \$100 \$46 VSS sg13_lv_nmos L=0.13U W=1U AS=0.19P AD=0.19P PS=1.38U
+ PD=1.38U
xM$36 VSS Vref \$72 VSS sg13_lv_nmos L=0.13U W=1U AS=0.19P AD=0.34P PS=1.38U
+ PD=2.68U
xM$37 \$73 \$46 VSS VSS sg13_lv_nmos L=0.13U W=1U AS=0.34P AD=0.34P PS=2.68U
+ PD=2.68U
xM$38 \$138 \$100 VSS VSS sg13_lv_nmos L=0.13U W=1U AS=0.34P AD=0.34P PS=2.68U
+ PD=2.68U
xM$39 \$74 \$71 VSS VSS sg13_lv_nmos L=0.13U W=1U AS=0.34P AD=0.34P PS=2.68U
+ PD=2.68U
xM$40 \$139 \$130 VSS VSS sg13_lv_nmos L=0.13U W=1U AS=0.34P AD=0.34P PS=2.68U
+ PD=2.68U
xM$41 \$167 \$100 VSS VSS sg13_lv_nmos L=0.13U W=1U AS=0.34P AD=0.19P PS=2.68U
+ PD=1.38U
xM$42 \$133 \$130 \$167 VSS sg13_lv_nmos L=0.13U W=1U AS=0.19P AD=0.19P PS=1.38U
+ PD=1.38U
xM$43 \$168 \$139 \$133 VSS sg13_lv_nmos L=0.13U W=1U AS=0.19P AD=0.19P PS=1.38U
+ PD=1.38U
xM$44 VSS \$138 \$168 VSS sg13_lv_nmos L=0.13U W=1U AS=0.19P AD=0.34P PS=1.38U
+ PD=2.68U
xM$45 \$75 \$46 VSS VSS sg13_lv_nmos L=0.13U W=1U AS=0.34P AD=0.19P PS=2.68U
+ PD=1.38U
xM$46 \$76 \$71 \$75 VSS sg13_lv_nmos L=0.13U W=1U AS=0.19P AD=0.19P PS=1.38U
+ PD=1.38U
xM$47 \$47 \$74 \$76 VSS sg13_lv_nmos L=0.13U W=1U AS=0.19P AD=0.19P PS=1.38U
+ PD=1.38U
xM$48 VSS \$73 \$47 VSS sg13_lv_nmos L=0.13U W=1U AS=0.19P AD=0.34P PS=1.38U
+ PD=2.68U
xM$49 \$140 \$133 VSS VSS sg13_lv_nmos L=0.13U W=1U AS=0.34P AD=0.34P PS=2.68U
+ PD=2.68U
xM$50 \$77 \$76 VSS VSS sg13_lv_nmos L=0.13U W=1U AS=0.34P AD=0.34P PS=2.68U
+ PD=2.68U
xM$51 \$135 \$140 VSS VSS sg13_lv_nmos L=0.13U W=1U AS=0.34P AD=0.19P PS=2.68U
+ PD=1.38U
xM$52 VSS \$140 \$135 VSS sg13_lv_nmos L=0.13U W=1U AS=0.19P AD=0.19P PS=1.38U
+ PD=1.38U
xM$53 \$135 \$140 VSS VSS sg13_lv_nmos L=0.13U W=1U AS=0.19P AD=0.34P PS=1.38U
+ PD=2.68U
xM$54 \$78 \$77 VSS VSS sg13_lv_nmos L=0.13U W=1U AS=0.34P AD=0.19P PS=2.68U
+ PD=1.38U
xM$55 VSS \$77 \$78 VSS sg13_lv_nmos L=0.13U W=1U AS=0.19P AD=0.19P PS=1.38U
+ PD=1.38U
xM$56 \$78 \$77 VSS VSS sg13_lv_nmos L=0.13U W=1U AS=0.19P AD=0.34P PS=1.38U
+ PD=2.68U
xM$57 \$195 Vctr|Vx VSS VSS sg13_lv_nmos L=0.13U W=1U AS=0.34P AD=0.34P PS=2.68U
+ PD=2.68U
xM$58 \$164 RST VSS VSS sg13_lv_nmos L=0.13U W=1U AS=0.34P AD=0.19P
+ PS=2.68U PD=1.38U
xM$59 \$176 \$223 \$164 VSS sg13_lv_nmos L=0.13U W=1U AS=0.19P AD=0.19P PS=1.38U
+ PD=1.38U
xM$60 VSS Vctr|Vx \$176 VSS sg13_lv_nmos L=0.13U W=1U AS=0.19P AD=0.34P PS=1.38U
+ PD=2.68U
xM$61 \$165 RST VSS VSS sg13_lv_nmos L=0.13U W=1U AS=0.34P AD=0.19P
+ PS=2.68U PD=1.38U
xM$62 \$196 \$224 \$165 VSS sg13_lv_nmos L=0.13U W=1U AS=0.19P AD=0.19P PS=1.38U
+ PD=1.38U
xM$63 VSS Vref \$196 VSS sg13_lv_nmos L=0.13U W=1U AS=0.19P AD=0.34P PS=1.38U
+ PD=2.68U
xM$64 \$197 \$165 VSS VSS sg13_lv_nmos L=0.13U W=1U AS=0.34P AD=0.34P PS=2.68U
+ PD=2.68U
xM$65 \$198 \$164 VSS VSS sg13_lv_nmos L=0.13U W=1U AS=0.34P AD=0.34P PS=2.68U
+ PD=2.68U
xM$66 \$199 \$165 VSS VSS sg13_lv_nmos L=0.13U W=1U AS=0.34P AD=0.19P PS=2.68U
+ PD=1.38U
xM$67 \$200 \$164 \$199 VSS sg13_lv_nmos L=0.13U W=1U AS=0.19P AD=0.19P PS=1.38U
+ PD=1.38U
xM$68 \$201 \$198 \$200 VSS sg13_lv_nmos L=0.13U W=1U AS=0.19P AD=0.19P PS=1.38U
+ PD=1.38U
xM$69 VSS \$197 \$201 VSS sg13_lv_nmos L=0.13U W=1U AS=0.19P AD=0.34P PS=1.38U
+ PD=2.68U
xM$70 \$202 \$200 VSS VSS sg13_lv_nmos L=0.13U W=1U AS=0.34P AD=0.34P PS=2.68U
+ PD=2.68U
xM$71 \$177 \$202 VSS VSS sg13_lv_nmos L=0.13U W=1U AS=0.34P AD=0.19P PS=2.68U
+ PD=1.38U
xM$72 VSS \$202 \$177 VSS sg13_lv_nmos L=0.13U W=1U AS=0.19P AD=0.19P PS=1.38U
+ PD=1.38U
xM$73 \$177 \$202 VSS VSS sg13_lv_nmos L=0.13U W=1U AS=0.19P AD=0.34P PS=1.38U
+ PD=2.68U
xM$74 \$223 VSS VSS VSS sg13_lv_nmos L=0.13U W=1U AS=0.34P AD=0.19P PS=2.68U
+ PD=1.38U
xM$75 \$292 \$286 \$223 VSS sg13_lv_nmos L=0.13U W=1U AS=0.19P AD=0.19P PS=1.38U
+ PD=1.38U
xM$76 VSS Vctr|Vx \$292 VSS sg13_lv_nmos L=0.13U W=1U AS=0.19P AD=0.34P PS=1.38U
+ PD=2.68U
xM$77 \$286 RST VSS VSS sg13_lv_nmos L=0.13U W=1U AS=0.34P AD=0.19P
+ PS=2.68U PD=1.38U
xM$78 \$298 \$71 \$286 VSS sg13_lv_nmos L=0.13U W=1U AS=0.19P AD=0.19P PS=1.38U
+ PD=1.38U
xM$79 VSS Vctr|Vx \$298 VSS sg13_lv_nmos L=0.13U W=1U AS=0.19P AD=0.34P PS=1.38U
+ PD=2.68U
xM$80 \$224 VSS VSS VSS sg13_lv_nmos L=0.13U W=1U AS=0.34P AD=0.19P PS=2.68U
+ PD=1.38U
xM$81 \$293 \$287 \$224 VSS sg13_lv_nmos L=0.13U W=1U AS=0.19P AD=0.19P PS=1.38U
+ PD=1.38U
xM$82 VSS Vref \$293 VSS sg13_lv_nmos L=0.13U W=1U AS=0.19P AD=0.34P PS=1.38U
+ PD=2.68U
xM$83 \$287 RST VSS VSS sg13_lv_nmos L=0.13U W=1U AS=0.34P AD=0.19P
+ PS=2.68U PD=1.38U
xM$84 \$299 \$46 \$287 VSS sg13_lv_nmos L=0.13U W=1U AS=0.19P AD=0.19P PS=1.38U
+ PD=1.38U
xM$85 VSS Vref \$299 VSS sg13_lv_nmos L=0.13U W=1U AS=0.19P AD=0.34P PS=1.38U
+ PD=2.68U
xM$86 \$262 \$224 VSS VSS sg13_lv_nmos L=0.13U W=1U AS=0.34P AD=0.34P PS=2.68U
+ PD=2.68U
xM$87 \$318 \$287 VSS VSS sg13_lv_nmos L=0.13U W=1U AS=0.34P AD=0.34P PS=2.68U
+ PD=2.68U
xM$88 \$319 \$286 VSS VSS sg13_lv_nmos L=0.13U W=1U AS=0.34P AD=0.34P PS=2.68U
+ PD=2.68U
xM$89 \$263 \$223 VSS VSS sg13_lv_nmos L=0.13U W=1U AS=0.34P AD=0.34P PS=2.68U
+ PD=2.68U
xM$90 \$294 \$224 VSS VSS sg13_lv_nmos L=0.13U W=1U AS=0.34P AD=0.19P PS=2.68U
+ PD=1.38U
xM$91 \$257 \$223 \$294 VSS sg13_lv_nmos L=0.13U W=1U AS=0.19P AD=0.19P PS=1.38U
+ PD=1.38U
xM$92 \$291 \$263 \$257 VSS sg13_lv_nmos L=0.13U W=1U AS=0.19P AD=0.19P PS=1.38U
+ PD=1.38U
xM$93 VSS \$262 \$291 VSS sg13_lv_nmos L=0.13U W=1U AS=0.19P AD=0.34P PS=1.38U
+ PD=2.68U
xM$94 \$300 \$287 VSS VSS sg13_lv_nmos L=0.13U W=1U AS=0.34P AD=0.19P PS=2.68U
+ PD=1.38U
xM$95 \$320 \$286 \$300 VSS sg13_lv_nmos L=0.13U W=1U AS=0.19P AD=0.19P PS=1.38U
+ PD=1.38U
xM$96 \$301 \$319 \$320 VSS sg13_lv_nmos L=0.13U W=1U AS=0.19P AD=0.19P PS=1.38U
+ PD=1.38U
xM$97 VSS \$318 \$301 VSS sg13_lv_nmos L=0.13U W=1U AS=0.19P AD=0.34P PS=1.38U
+ PD=2.68U
xM$98 \$259 \$257 VSS VSS sg13_lv_nmos L=0.13U W=1U AS=0.34P AD=0.34P PS=2.68U
+ PD=2.68U
xM$99 \$321 \$320 VSS VSS sg13_lv_nmos L=0.13U W=1U AS=0.34P AD=0.34P PS=2.68U
+ PD=2.68U
xM$100 \$322 \$321 VSS VSS sg13_lv_nmos L=0.13U W=1U AS=0.34P AD=0.19P PS=2.68U
+ PD=1.38U
xM$101 VSS \$321 \$322 VSS sg13_lv_nmos L=0.13U W=1U AS=0.19P AD=0.19P PS=1.38U
+ PD=1.38U
xM$102 \$322 \$321 VSS VSS sg13_lv_nmos L=0.13U W=1U AS=0.19P AD=0.34P PS=1.38U
+ PD=2.68U
xM$103 \$260 \$259 VSS VSS sg13_lv_nmos L=0.13U W=1U AS=0.34P AD=0.19P PS=2.68U
+ PD=1.38U
xM$104 VSS \$259 \$260 VSS sg13_lv_nmos L=0.13U W=1U AS=0.19P AD=0.19P PS=1.38U
+ PD=1.38U
xM$105 \$260 \$259 VSS VSS sg13_lv_nmos L=0.13U W=1U AS=0.19P AD=0.34P PS=1.38U
+ PD=2.68U
xM$106 VDD \$7 RST VDD sg13_lv_pmos L=0.13U W=2U AS=0.68P AD=0.38P PS=4.68U
+ PD=2.38U
xM$107 RST \$7 VDD VDD sg13_lv_pmos L=0.13U W=2U AS=0.38P AD=0.38P PS=2.38U
+ PD=2.38U
xM$108 VDD \$7 RST VDD sg13_lv_pmos L=0.13U W=2U AS=0.38P AD=0.68P PS=2.38U
+ PD=4.68U
xM$109 VDD \$8 \$7 VDD sg13_lv_pmos L=0.13U W=2U AS=0.68P AD=0.68P PS=4.68U
+ PD=4.68U
xM$110 VDD \$39 \$8 VDD sg13_lv_pmos L=0.13U W=2U AS=0.68P AD=0.38P PS=4.68U
+ PD=2.38U
xM$111 \$3 Vout|vCMP VDD VDD sg13_lv_pmos L=0.13U W=2U AS=0.38P AD=0.38P
+ PS=2.38U PD=2.38U
xM$112 \$39 RST|Ven \$3 VDD sg13_lv_pmos L=0.13U W=2U AS=0.38P AD=0.68P PS=2.38U
+ PD=4.68U
xM$113 VDD \$40 SPIKE VDD sg13_lv_pmos L=0.13U W=2U AS=0.68P AD=0.38P
+ PS=4.68U PD=2.38U
xM$114 SPIKE \$40 VDD VDD sg13_lv_pmos L=0.13U W=2U AS=0.38P AD=0.38P
+ PS=2.38U PD=2.38U
xM$115 VDD \$40 SPIKE VDD sg13_lv_pmos L=0.13U W=2U AS=0.38P AD=0.68P
+ PS=2.38U PD=4.68U
xM$116 VDD \$5 \$40 VDD sg13_lv_pmos L=0.13U W=2U AS=0.68P AD=0.68P PS=4.68U
+ PD=4.68U
xM$117 VDD \$6 \$5 VDD sg13_lv_pmos L=0.13U W=2U AS=0.68P AD=0.38P PS=4.68U
+ PD=2.38U
xM$118 \$6 \$9 VDD VDD sg13_lv_pmos L=0.13U W=2U AS=0.38P AD=0.38P PS=2.38U
+ PD=2.38U
xM$119 VDD Vout|vCMP \$6 VDD sg13_lv_pmos L=0.13U W=2U AS=0.38P AD=0.68P
+ PS=2.38U PD=4.68U
xM$120 VDD \$10 \$9 VDD sg13_lv_pmos L=0.65U W=2U AS=0.68P AD=0.68P PS=4.68U
+ PD=4.68U
xM$121 VDD \$11 \$10 VDD sg13_lv_pmos L=0.65U W=2U AS=0.68P AD=0.68P PS=4.68U
+ PD=4.68U
xM$122 VDD \$12 \$11 VDD sg13_lv_pmos L=0.65U W=2U AS=0.68P AD=0.68P PS=4.68U
+ PD=4.68U
xM$123 VDD \$13 \$12 VDD sg13_lv_pmos L=0.65U W=2U AS=0.68P AD=0.68P PS=4.68U
+ PD=4.68U
xM$124 VDD Vout|vCMP \$13 VDD sg13_lv_pmos L=0.65U W=2U AS=0.68P AD=0.68P
+ PS=4.68U PD=4.68U
xM$125 \$136 \$136 VDD VDD sg13_lv_pmos L=0.13U W=2U AS=0.68P AD=0.68P PS=4.68U
+ PD=4.68U
xM$126 \$130 VDD VDD VDD sg13_lv_pmos L=0.13U W=2U AS=0.68P AD=0.38P PS=4.68U
+ PD=2.38U
xM$127 \$131 \$164 \$130 VDD sg13_lv_pmos L=0.13U W=2U AS=0.38P AD=0.38P
+ PS=2.38U PD=2.38U
xM$128 VDD \$195 \$131 VDD sg13_lv_pmos L=0.13U W=2U AS=0.38P AD=0.68P PS=2.38U
+ PD=4.68U
xM$129 \$71 VDD VDD VDD sg13_lv_pmos L=0.13U W=2U AS=0.68P AD=0.38P PS=4.68U
+ PD=2.38U
xM$130 \$104 \$130 \$71 VDD sg13_lv_pmos L=0.13U W=2U AS=0.38P AD=0.38P PS=2.38U
+ PD=2.38U
xM$131 VDD \$195 \$104 VDD sg13_lv_pmos L=0.13U W=2U AS=0.38P AD=0.68P PS=2.38U
+ PD=4.68U
xM$132 \$100 VDD VDD VDD sg13_lv_pmos L=0.13U W=2U AS=0.68P AD=0.38P PS=4.68U
+ PD=2.38U
xM$133 \$137 \$165 \$100 VDD sg13_lv_pmos L=0.13U W=2U AS=0.38P AD=0.38P
+ PS=2.38U PD=2.38U
xM$134 VDD \$136 \$137 VDD sg13_lv_pmos L=0.13U W=2U AS=0.38P AD=0.68P PS=2.38U
+ PD=4.68U
xM$135 \$46 VDD VDD VDD sg13_lv_pmos L=0.13U W=2U AS=0.68P AD=0.38P PS=4.68U
+ PD=2.38U
xM$136 \$105 \$100 \$46 VDD sg13_lv_pmos L=0.13U W=2U AS=0.38P AD=0.38P PS=2.38U
+ PD=2.38U
xM$137 VDD \$136 \$105 VDD sg13_lv_pmos L=0.13U W=2U AS=0.38P AD=0.68P PS=2.38U
+ PD=4.68U
xM$138 \$73 \$46 VDD VDD sg13_lv_pmos L=0.13U W=2U AS=0.68P AD=0.68P PS=4.68U
+ PD=4.68U
xM$139 \$138 \$100 VDD VDD sg13_lv_pmos L=0.13U W=2U AS=0.68P AD=0.68P PS=4.68U
+ PD=4.68U
xM$140 \$74 \$71 VDD VDD sg13_lv_pmos L=0.13U W=2U AS=0.68P AD=0.68P PS=4.68U
+ PD=4.68U
xM$141 \$139 \$130 VDD VDD sg13_lv_pmos L=0.13U W=2U AS=0.68P AD=0.68P PS=4.68U
+ PD=4.68U
xM$142 \$132 \$100 VDD VDD sg13_lv_pmos L=0.13U W=2U AS=0.68P AD=0.38P PS=4.68U
+ PD=2.38U
xM$143 \$133 \$139 \$132 VDD sg13_lv_pmos L=0.13U W=2U AS=0.38P AD=0.38P
+ PS=2.38U PD=2.38U
xM$144 \$134 \$130 \$133 VDD sg13_lv_pmos L=0.13U W=2U AS=0.38P AD=0.38P
+ PS=2.38U PD=2.38U
xM$145 VDD \$138 \$134 VDD sg13_lv_pmos L=0.13U W=2U AS=0.38P AD=0.68P PS=2.38U
+ PD=4.68U
xM$146 \$106 \$46 VDD VDD sg13_lv_pmos L=0.13U W=2U AS=0.68P AD=0.38P PS=4.68U
+ PD=2.38U
xM$147 \$76 \$74 \$106 VDD sg13_lv_pmos L=0.13U W=2U AS=0.38P AD=0.38P PS=2.38U
+ PD=2.38U
xM$148 \$107 \$71 \$76 VDD sg13_lv_pmos L=0.13U W=2U AS=0.38P AD=0.38P PS=2.38U
+ PD=2.38U
xM$149 VDD \$73 \$107 VDD sg13_lv_pmos L=0.13U W=2U AS=0.38P AD=0.68P PS=2.38U
+ PD=4.68U
xM$150 \$140 \$133 VDD VDD sg13_lv_pmos L=0.13U W=2U AS=0.68P AD=0.68P PS=4.68U
+ PD=4.68U
xM$151 \$77 \$76 VDD VDD sg13_lv_pmos L=0.13U W=2U AS=0.68P AD=0.68P PS=4.68U
+ PD=4.68U
xM$152 \$78 \$77 VDD VDD sg13_lv_pmos L=0.13U W=2U AS=0.68P AD=0.38P PS=4.68U
+ PD=2.38U
xM$153 VDD \$77 \$78 VDD sg13_lv_pmos L=0.13U W=2U AS=0.38P AD=0.38P PS=2.38U
+ PD=2.38U
xM$154 \$78 \$77 VDD VDD sg13_lv_pmos L=0.13U W=2U AS=0.38P AD=0.68P PS=2.38U
+ PD=4.68U
xM$155 \$135 \$140 VDD VDD sg13_lv_pmos L=0.13U W=2U AS=0.68P AD=0.38P PS=4.68U
+ PD=2.38U
xM$156 VDD \$140 \$135 VDD sg13_lv_pmos L=0.13U W=2U AS=0.38P AD=0.38P PS=2.38U
+ PD=2.38U
xM$157 \$135 \$140 VDD VDD sg13_lv_pmos L=0.13U W=2U AS=0.38P AD=0.68P PS=2.38U
+ PD=4.68U
xM$158 Vout|vCMP \$14 VDD VDD sg13_lv_pmos L=0.13U W=2U AS=0.68P AD=0.38P
+ PS=4.68U PD=2.38U
xM$159 VDD \$14 Vout|vCMP VDD sg13_lv_pmos L=0.13U W=2U AS=0.38P AD=0.38P
+ PS=2.38U PD=2.38U
xM$160 \$14 VOUT|Vin VDD VDD sg13_lv_pmos L=0.13U W=2U AS=0.38P AD=0.38P
+ PS=2.38U PD=2.38U
xM$161 VDD VOUT|Vin \$14 VDD sg13_lv_pmos L=0.13U W=2U AS=0.38P AD=0.68P
+ PS=2.38U PD=4.68U
xM$162 \$195 \$195 VDD VDD sg13_lv_pmos L=0.13U W=2U AS=0.68P AD=0.68P PS=4.68U
+ PD=4.68U
xM$163 \$164 VDD VDD VDD sg13_lv_pmos L=0.13U W=2U AS=0.68P AD=0.38P PS=4.68U
+ PD=2.38U
xM$164 \$228 \$223 \$164 VDD sg13_lv_pmos L=0.13U W=2U AS=0.38P AD=0.38P
+ PS=2.38U PD=2.38U
xM$165 VDD \$195 \$228 VDD sg13_lv_pmos L=0.13U W=2U AS=0.38P AD=0.68P PS=2.38U
+ PD=4.68U
xM$166 \$165 VDD VDD VDD sg13_lv_pmos L=0.13U W=2U AS=0.68P AD=0.38P PS=4.68U
+ PD=2.38U
xM$167 \$229 \$224 \$165 VDD sg13_lv_pmos L=0.13U W=2U AS=0.38P AD=0.38P
+ PS=2.38U PD=2.38U
xM$168 VDD \$136 \$229 VDD sg13_lv_pmos L=0.13U W=2U AS=0.38P AD=0.68P PS=2.38U
+ PD=4.68U
xM$169 \$197 \$165 VDD VDD sg13_lv_pmos L=0.13U W=2U AS=0.68P AD=0.68P PS=4.68U
+ PD=4.68U
xM$170 \$198 \$164 VDD VDD sg13_lv_pmos L=0.13U W=2U AS=0.68P AD=0.68P PS=4.68U
+ PD=4.68U
xM$171 \$231 \$165 VDD VDD sg13_lv_pmos L=0.13U W=2U AS=0.68P AD=0.38P PS=4.68U
+ PD=2.38U
xM$172 \$200 \$198 \$231 VDD sg13_lv_pmos L=0.13U W=2U AS=0.38P AD=0.38P
+ PS=2.38U PD=2.38U
xM$173 \$230 \$164 \$200 VDD sg13_lv_pmos L=0.13U W=2U AS=0.38P AD=0.38P
+ PS=2.38U PD=2.38U
xM$174 VDD \$197 \$230 VDD sg13_lv_pmos L=0.13U W=2U AS=0.38P AD=0.68P PS=2.38U
+ PD=4.68U
xM$175 \$202 \$200 VDD VDD sg13_lv_pmos L=0.13U W=2U AS=0.68P AD=0.68P PS=4.68U
+ PD=4.68U
xM$176 \$177 \$202 VDD VDD sg13_lv_pmos L=0.13U W=2U AS=0.68P AD=0.38P PS=4.68U
+ PD=2.38U
xM$177 VDD \$202 \$177 VDD sg13_lv_pmos L=0.13U W=2U AS=0.38P AD=0.38P PS=2.38U
+ PD=2.38U
xM$178 \$177 \$202 VDD VDD sg13_lv_pmos L=0.13U W=2U AS=0.38P AD=0.68P PS=2.38U
+ PD=4.68U
xM$179 \$223 VDD VDD VDD sg13_lv_pmos L=0.13U W=2U AS=0.68P AD=0.38P PS=4.68U
+ PD=2.38U
xM$180 \$261 \$286 \$223 VDD sg13_lv_pmos L=0.13U W=2U AS=0.38P AD=0.38P
+ PS=2.38U PD=2.38U
xM$181 VDD \$195 \$261 VDD sg13_lv_pmos L=0.13U W=2U AS=0.38P AD=0.68P PS=2.38U
+ PD=4.68U
xM$182 \$286 VDD VDD VDD sg13_lv_pmos L=0.13U W=2U AS=0.68P AD=0.38P PS=4.68U
+ PD=2.38U
xM$183 \$345 \$71 \$286 VDD sg13_lv_pmos L=0.13U W=2U AS=0.38P AD=0.38P PS=2.38U
+ PD=2.38U
xM$184 VDD \$195 \$345 VDD sg13_lv_pmos L=0.13U W=2U AS=0.38P AD=0.68P PS=2.38U
+ PD=4.68U
xM$185 \$287 VDD VDD VDD sg13_lv_pmos L=0.13U W=2U AS=0.68P AD=0.38P PS=4.68U
+ PD=2.38U
xM$186 \$346 \$46 \$287 VDD sg13_lv_pmos L=0.13U W=2U AS=0.38P AD=0.38P PS=2.38U
+ PD=2.38U
xM$187 VDD \$136 \$346 VDD sg13_lv_pmos L=0.13U W=2U AS=0.38P AD=0.68P PS=2.38U
+ PD=4.68U
xM$188 \$224 VDD VDD VDD sg13_lv_pmos L=0.13U W=2U AS=0.68P AD=0.38P PS=4.68U
+ PD=2.38U
xM$189 \$255 \$287 \$224 VDD sg13_lv_pmos L=0.13U W=2U AS=0.38P AD=0.38P
+ PS=2.38U PD=2.38U
xM$190 VDD \$136 \$255 VDD sg13_lv_pmos L=0.13U W=2U AS=0.38P AD=0.68P PS=2.38U
+ PD=4.68U
xM$191 \$318 \$287 VDD VDD sg13_lv_pmos L=0.13U W=2U AS=0.68P AD=0.68P PS=4.68U
+ PD=4.68U
xM$192 \$262 \$224 VDD VDD sg13_lv_pmos L=0.13U W=2U AS=0.68P AD=0.68P PS=4.68U
+ PD=4.68U
xM$193 \$263 \$223 VDD VDD sg13_lv_pmos L=0.13U W=2U AS=0.68P AD=0.68P PS=4.68U
+ PD=4.68U
xM$194 \$319 \$286 VDD VDD sg13_lv_pmos L=0.13U W=2U AS=0.68P AD=0.68P PS=4.68U
+ PD=4.68U
xM$195 \$256 \$224 VDD VDD sg13_lv_pmos L=0.13U W=2U AS=0.68P AD=0.38P PS=4.68U
+ PD=2.38U
xM$196 \$257 \$263 \$256 VDD sg13_lv_pmos L=0.13U W=2U AS=0.38P AD=0.38P
+ PS=2.38U PD=2.38U
xM$197 \$258 \$223 \$257 VDD sg13_lv_pmos L=0.13U W=2U AS=0.38P AD=0.38P
+ PS=2.38U PD=2.38U
xM$198 VDD \$262 \$258 VDD sg13_lv_pmos L=0.13U W=2U AS=0.38P AD=0.68P PS=2.38U
+ PD=4.68U
xM$199 \$347 \$287 VDD VDD sg13_lv_pmos L=0.13U W=2U AS=0.68P AD=0.38P PS=4.68U
+ PD=2.38U
xM$200 \$320 \$319 \$347 VDD sg13_lv_pmos L=0.13U W=2U AS=0.38P AD=0.38P
+ PS=2.38U PD=2.38U
xM$201 \$348 \$286 \$320 VDD sg13_lv_pmos L=0.13U W=2U AS=0.38P AD=0.38P
+ PS=2.38U PD=2.38U
xM$202 VDD \$318 \$348 VDD sg13_lv_pmos L=0.13U W=2U AS=0.38P AD=0.68P PS=2.38U
+ PD=4.68U
xM$203 \$259 \$257 VDD VDD sg13_lv_pmos L=0.13U W=2U AS=0.68P AD=0.68P PS=4.68U
+ PD=4.68U
xM$204 \$321 \$320 VDD VDD sg13_lv_pmos L=0.13U W=2U AS=0.68P AD=0.68P PS=4.68U
+ PD=4.68U
xM$205 \$322 \$321 VDD VDD sg13_lv_pmos L=0.13U W=2U AS=0.68P AD=0.38P PS=4.68U
+ PD=2.38U
xM$206 VDD \$321 \$322 VDD sg13_lv_pmos L=0.13U W=2U AS=0.38P AD=0.38P PS=2.38U
+ PD=2.38U
xM$207 \$322 \$321 VDD VDD sg13_lv_pmos L=0.13U W=2U AS=0.38P AD=0.68P PS=2.38U
+ PD=4.68U
xM$208 \$260 \$259 VDD VDD sg13_lv_pmos L=0.13U W=2U AS=0.68P AD=0.38P PS=4.68U
+ PD=2.38U
xM$209 VDD \$259 \$260 VDD sg13_lv_pmos L=0.13U W=2U AS=0.38P AD=0.38P PS=2.38U
+ PD=2.38U
xM$210 \$260 \$259 VDD VDD sg13_lv_pmos L=0.13U W=2U AS=0.38P AD=0.68P PS=2.38U
+ PD=4.68U
xR$211 VSS VSS sub! rppd w=0.5 l=0.5 ps=0 b=0 m=1
xR$212 VSS VSS sub! rppd w=0.5 l=0.5 ps=0 b=0 m=1
xR$213 VSS VSS sub! rppd w=0.5 l=0.5 ps=0 b=0 m=1
xR$214 VSS VSS sub! rppd w=0.5 l=0.5 ps=0 b=0 m=1
xR$215 \$78 VOUT|Vin sub! rppd w=0.5 l=0.5 ps=0 b=0 m=1
xR$216 VSS VSS sub! rppd w=0.5 l=0.5 ps=0 b=0 m=1
xR$217 VSS VSS sub! rppd w=0.5 l=0.5 ps=0 b=0 m=1
xR$218 \$78 VOUT|Vin sub! rppd w=0.5 l=0.5 ps=0 b=0 m=1
xR$219 VSS VSS sub! rppd w=0.5 l=0.5 ps=0 b=0 m=1
xR$220 VSS VSS sub! rppd w=0.5 l=0.5 ps=0 b=0 m=1
xR$221 VSS VSS sub! rppd w=0.5 l=0.5 ps=0 b=0 m=1
xR$222 VSS VSS sub! rppd w=0.5 l=0.5 ps=0 b=0 m=1
xR$223 VSS VSS sub! rppd w=0.5 l=0.5 ps=0 b=0 m=1
xR$224 VSS VSS sub! rppd w=0.5 l=0.5 ps=0 b=0 m=1
xR$225 VSS VSS sub! rppd w=0.5 l=0.5 ps=0 b=0 m=1
xR$226 VSS VSS sub! rppd w=0.5 l=0.5 ps=0 b=0 m=1
xR$227 \$135 VOUT|Vin sub! rppd w=0.5 l=0.5 ps=0 b=0 m=1
xR$228 VSS VSS sub! rppd w=0.5 l=0.5 ps=0 b=0 m=1
xR$229 VSS VSS sub! rppd w=0.5 l=0.5 ps=0 b=0 m=1
xR$230 \$135 VOUT|Vin sub! rppd w=0.5 l=0.5 ps=0 b=0 m=1
xR$231 VSS VSS sub! rppd w=0.5 l=0.5 ps=0 b=0 m=1
xR$232 VSS VSS sub! rppd w=0.5 l=0.5 ps=0 b=0 m=1
xR$233 VSS VSS sub! rppd w=0.5 l=0.5 ps=0 b=0 m=1
xR$234 VSS VSS sub! rppd w=0.5 l=0.5 ps=0 b=0 m=1
xR$235 VSS VSS sub! rppd w=0.5 l=0.5 ps=0 b=0 m=1
xR$236 VSS VSS sub! rppd w=0.5 l=0.5 ps=0 b=0 m=1
xR$237 VSS VSS sub! rppd w=0.5 l=0.5 ps=0 b=0 m=1
xR$238 VSS VSS sub! rppd w=0.5 l=0.5 ps=0 b=0 m=1
xR$239 \$177 VOUT|Vin sub! rppd w=0.5 l=0.5 ps=0 b=0 m=1
xR$240 VSS VSS sub! rppd w=0.5 l=0.5 ps=0 b=0 m=1
xR$241 VSS VSS sub! rppd w=0.5 l=0.5 ps=0 b=0 m=1
xR$242 \$177 VOUT|Vin sub! rppd w=0.5 l=0.5 ps=0 b=0 m=1
xR$243 VSS VSS sub! rppd w=0.5 l=0.5 ps=0 b=0 m=1
xR$244 VSS VSS sub! rppd w=0.5 l=0.5 ps=0 b=0 m=1
xR$245 VSS VSS sub! rppd w=0.5 l=0.5 ps=0 b=0 m=1
xR$246 VSS VSS sub! rppd w=0.5 l=0.5 ps=0 b=0 m=1
xR$247 VSS VSS sub! rppd w=0.5 l=0.5 ps=0 b=0 m=1
xR$248 VSS VSS sub! rppd w=0.5 l=0.5 ps=0 b=0 m=1
xR$249 VSS VSS sub! rppd w=0.5 l=0.5 ps=0 b=0 m=1
xR$250 VSS VSS sub! rppd w=0.5 l=0.5 ps=0 b=0 m=1
xR$251 \$260 VOUT|Vin sub! rppd w=0.5 l=0.5 ps=0 b=0 m=1
xR$252 VSS VSS sub! rppd w=0.5 l=0.5 ps=0 b=0 m=1
xR$253 VSS VSS sub! rppd w=0.5 l=0.5 ps=0 b=0 m=1
xR$254 \$260 VOUT|Vin sub! rppd w=0.5 l=0.5 ps=0 b=0 m=1
xR$255 VSS VSS sub! rppd w=0.5 l=0.5 ps=0 b=0 m=1
xR$256 VSS VSS sub! rppd w=0.5 l=0.5 ps=0 b=0 m=1
xR$257 VSS VSS sub! rppd w=0.5 l=0.5 ps=0 b=0 m=1
xR$258 VSS VSS sub! rppd w=0.5 l=0.5 ps=0 b=0 m=1
xR$259 VSS VSS sub! rppd w=0.5 l=0.5 ps=0 b=0 m=1
xR$260 VSS VSS sub! rppd w=0.5 l=0.5 ps=0 b=0 m=1
xR$261 VSS VSS sub! rppd w=0.5 l=0.5 ps=0 b=0 m=1
xR$262 VSS VSS sub! rppd w=0.5 l=0.5 ps=0 b=0 m=1
xR$263 \$322 VOUT|Vin sub! rppd w=0.5 l=0.5 ps=0 b=0 m=1
xR$264 VSS VSS sub! rppd w=0.5 l=0.5 ps=0 b=0 m=1
xR$265 VSS VSS sub! rppd w=0.5 l=0.5 ps=0 b=0 m=1
xR$266 \$322 VOUT|Vin sub! rppd w=0.5 l=0.5 ps=0 b=0 m=1
xR$267 VSS VSS sub! rppd w=0.5 l=0.5 ps=0 b=0 m=1
xR$268 VSS VSS sub! rppd w=0.5 l=0.5 ps=0 b=0 m=1
xR$269 VSS VSS sub! rppd w=0.5 l=0.5 ps=0 b=0 m=1
xR$270 VSS VSS sub! rppd w=0.5 l=0.5 ps=0 b=0 m=1
xR$271 VDD VDD sub! rhigh w=0.5 l=4 ps=0 b=0 m=1
xR$272 VDD VDD sub! rhigh w=0.5 l=4 ps=0 b=0 m=1
xR$273 VDD VDD sub! rhigh w=0.5 l=4 ps=0 b=0 m=1
xR$274 VDD VDD sub! rhigh w=0.5 l=4 ps=0 b=0 m=1
xR$275 \$375 \$376 sub! rhigh w=0.5 l=4 ps=0 b=0 m=1
xR$276 \$377 \$375 sub! rhigh w=0.5 l=4 ps=0 b=0 m=1
xR$277 \$378 \$379 sub! rhigh w=0.5 l=4 ps=0 b=0 m=1
xR$278 \$380 \$378 sub! rhigh w=0.5 l=4 ps=0 b=0 m=1
xR$279 Vctr|Vx \$376 sub! rhigh w=0.5 l=4 ps=0 b=0 m=1
xR$280 \$377 \$381 sub! rhigh w=0.5 l=4 ps=0 b=0 m=1
xR$281 \$381 \$379 sub! rhigh w=0.5 l=4 ps=0 b=0 m=1
xR$282 \$380 VOUT|Vin sub! rhigh w=0.5 l=4 ps=0 b=0 m=1
xR$283 VDD VDD sub! rhigh w=0.5 l=4 ps=0 b=0 m=1
xR$284 VDD VDD sub! rhigh w=0.5 l=4 ps=0 b=0 m=1
xR$285 VDD VDD sub! rhigh w=0.5 l=4 ps=0 b=0 m=1
xR$286 VDD VDD sub! rhigh w=0.5 l=4 ps=0 b=0 m=1
Cext_1 \$10 \$11 225.704a
Cext_2 \$10 \$6 4.86874a
Cext_3 \$10 \$76 7.43145a
Cext_4 \$10 \$77 2.16766a
Cext_5 \$10 \$9 169.877a
Cext_6 \$10 RST|Ven 106.65a
Cext_7 \$10 SPIKE 0.274934a
Cext_8 \$10 VDD 329.15a
Cext_9 \$10 Vout|vCMP 251.602a
Cext_10 \$10 VSS 202.436a
Cext_11 \$10 VSUBS 809.785a
Cext_12 \$100 \$104 0.146273a
Cext_13 \$100 \$105 41.1301a
Cext_14 \$100 \$130 966.114a
Cext_15 \$100 \$131 0.135089a
Cext_16 \$100 \$132 19.3541a
Cext_17 \$100 \$133 13.8067a
Cext_18 \$100 \$136 758.967a
Cext_19 \$100 \$137 207.365a
Cext_20 \$100 \$138 211.503a
Cext_21 \$100 \$139 267.592a
Cext_22 \$100 \$164 9.30732a
Cext_23 \$100 \$165 265.902a
Cext_24 \$100 \$167 9.4977a
Cext_25 \$100 \$172 98.0717a
Cext_26 \$100 \$195 10.1452a
Cext_27 \$100 \$198 0.498248a
Cext_28 \$100 \$39 0.405347a
Cext_29 \$100 \$46 632.576a
Cext_30 \$100 \$71 29.2121a
Cext_31 \$100 \$72 21.937a
Cext_32 \$100 \$73 0.197475a
Cext_33 \$100 \$74 0.497612a
Cext_34 \$100 \$76 0.309799a
Cext_35 \$100 RST|Ven 0.855244a
Cext_36 \$100 RST 1.08403f
Cext_37 \$100 SPIKE 6.77769a
Cext_38 \$100 Vctr|Vx 4.79911a
Cext_39 \$100 VDD 563.33a
Cext_40 \$100 Vref 244.301a
Cext_41 \$100 VSS 268.741a
Cext_42 \$100 VSUBS 1.35228f
Cext_43 \$104 \$130 46.1099a
Cext_44 \$104 \$136 0.6349a
Cext_45 \$104 \$164 0.518582a
Cext_46 \$104 \$195 21.3883a
Cext_47 \$104 \$71 211.987a
Cext_48 \$104 VDD 236.006a
Cext_49 \$104 VSUBS 29.68a
Cext_50 \$105 \$130 0.391907a
Cext_51 \$105 \$136 22.3293a
Cext_52 \$105 \$165 0.518582a
Cext_53 \$105 \$46 211.829a
Cext_54 \$105 \$71 11.9453a
Cext_55 \$105 VDD 237.778a
Cext_56 \$105 VSUBS 29.5864a
Cext_57 \$106 \$130 0.124398a
Cext_58 \$106 \$139 0.233118a
Cext_59 \$106 \$46 20.4947a
Cext_60 \$106 \$71 2.58383a
Cext_61 \$106 \$74 56.0763a
Cext_62 \$106 \$75 0.185029a
Cext_63 \$106 \$76 199.584a
Cext_64 \$106 VDD 216.886a
Cext_65 \$106 VSUBS 27.9851a
Cext_66 \$107 \$133 0.482027a
Cext_67 \$107 \$139 0.184706a
Cext_68 \$107 \$46 0.597278a
Cext_69 \$107 \$47 0.185029a
Cext_70 \$107 \$71 29.198a
Cext_71 \$107 \$73 19.659a
Cext_72 \$107 \$74 3.56119a
Cext_73 \$107 \$76 210.077a
Cext_74 \$107 VDD 252.053a
Cext_75 \$107 VSUBS 29.9313a
Cext_76 \$11 \$12 225.489a
Cext_77 \$11 \$6 0.666148a
Cext_78 \$11 \$77 8.41194a
Cext_79 \$11 \$78 1.6466a
Cext_80 \$11 RST|Ven 105.45a
Cext_81 \$11 SPIKE 0.159809a
Cext_82 \$11 VDD 332.925a
Cext_83 \$11 Vout|vCMP 204.648a
Cext_84 \$11 VSS 205.104a
Cext_85 \$11 VSUBS 808.074a
Cext_86 \$12 \$13 227.399a
Cext_87 \$12 \$6 0.318527a
Cext_88 \$12 \$78 3.23399a
Cext_89 \$12 RST|Ven 106.333a
Cext_90 \$12 VDD 336.002a
Cext_91 \$12 Vout|vCMP 198.731a
Cext_92 \$12 VSS 209.838a
Cext_93 \$12 VSUBS 810.951a
Cext_94 \$13 \$14 0.811338a
Cext_95 \$13 \$6 0.179409a
Cext_96 \$13 \$78 3.03543a
Cext_97 \$13 RST|Ven 106.665a
Cext_98 \$13 VDD 361.829a
Cext_99 \$13 Vout|vCMP 419.424a
Cext_100 \$13 VOUT|Vin 0.14806a
Cext_101 \$13 VSS 220.275a
Cext_102 \$13 VSUBS 816.497a
Cext_103 \$130 \$131 218.223a
Cext_104 \$130 \$132 1.61039a
Cext_105 \$130 \$133 396.474a
Cext_106 \$130 \$134 28.5519a
Cext_107 \$130 \$136 145.352a
Cext_108 \$130 \$137 13.0381a
Cext_109 \$130 \$138 692.9a
Cext_110 \$130 \$139 840.967a
Cext_111 \$130 \$140 9.09611a
Cext_112 \$130 \$164 253.17a
Cext_113 \$130 \$165 6.81589a
Cext_114 \$130 \$166 98.0717a
Cext_115 \$130 \$167 21.2936a
Cext_116 \$130 \$195 539.849a
Cext_117 \$130 \$197 1.19087a
Cext_118 \$130 \$198 0.588839a
Cext_119 \$130 \$45 20.7687a
Cext_120 \$130 \$46 359.18a
Cext_121 \$130 \$7 1.02968a
Cext_122 \$130 \$71 619.807a
Cext_123 \$130 \$73 0.699405a
Cext_124 \$130 \$74 0.379159a
Cext_125 \$130 \$76 0.865932a
Cext_126 \$130 RST 101.823a
Cext_127 \$130 SPIKE 0.465718a
Cext_128 \$130 Vctr|Vx 208.374a
Cext_129 \$130 VDD 588.037a
Cext_130 \$130 Vref 54.2387a
Cext_131 \$130 VSS 272.847a
Cext_132 \$130 VSUBS 1.41646f
Cext_133 \$131 \$136 1.96705a
Cext_134 \$131 \$164 31.8476a
Cext_135 \$131 \$195 22.7794a
Cext_136 \$131 \$71 0.915371a
Cext_137 \$131 VDD 236.496a
Cext_138 \$131 VSUBS 30.234a
Cext_139 \$132 \$133 200.016a
Cext_140 \$132 \$139 57.2982a
Cext_141 \$132 \$167 0.185029a
Cext_142 \$132 \$46 1.32314a
Cext_143 \$132 \$71 0.124398a
Cext_144 \$132 \$74 0.233118a
Cext_145 \$132 VDD 218.084a
Cext_146 \$132 VSUBS 28.5986a
Cext_147 \$133 \$134 210.642a
Cext_148 \$133 \$135 10.6747a
Cext_149 \$133 \$138 235.204a
Cext_150 \$133 \$139 358.871a
Cext_151 \$133 \$140 201.584a
Cext_152 \$133 \$165 0.341988a
Cext_153 \$133 \$167 98.0717a
Cext_154 \$133 \$168 98.0717a
Cext_155 \$133 \$198 0.443406a
Cext_156 \$133 \$200 10.7813a
Cext_157 \$133 \$46 1.99168a
Cext_158 \$133 \$71 0.865932a
Cext_159 \$133 \$73 0.727383a
Cext_160 \$133 \$76 20.202a
Cext_161 \$133 VDD 90.4777a
Cext_162 \$133 VSS 82.0775a
Cext_163 \$133 VSUBS 563.45a
Cext_164 \$134 \$138 19.6231a
Cext_165 \$134 \$139 3.56119a
Cext_166 \$134 \$168 0.185029a
Cext_167 \$134 \$46 0.841819a
Cext_168 \$134 \$74 0.184706a
Cext_169 \$134 \$76 0.482027a
Cext_170 \$134 VDD 252.721a
Cext_171 \$134 VSUBS 30.3212a
Cext_172 \$135 \$136 0.221681a
Cext_173 \$135 \$138 1.38144a
Cext_174 \$135 \$139 1.86333a
Cext_175 \$135 \$140 464.216a
Cext_176 \$135 \$177 28.7587a
Cext_177 \$135 \$202 1.37487a
Cext_178 \$135 \$46 0.338941a
Cext_179 \$135 \$77 1.70191a
Cext_180 \$135 \$78 36.2613a
Cext_181 \$135 VDD 650.51a
Cext_182 \$135 VOUT|Vin 134.851a
Cext_183 \$135 VSS 803.393a
Cext_184 \$135 VSUBS 576.099a
Cext_185 \$136 \$137 24.1635a
Cext_186 \$136 \$138 1.1535a
Cext_187 \$136 \$139 0.52211a
Cext_188 \$136 \$164 30.9917a
Cext_189 \$136 \$165 534.263a
Cext_190 \$136 \$172 0.7041a
Cext_191 \$136 \$195 45.1129a
Cext_192 \$136 \$196 1.82883a
Cext_193 \$136 \$197 0.867582a
Cext_194 \$136 \$198 0.168207a
Cext_195 \$136 \$223 30.6623a
Cext_196 \$136 \$224 742.72a
Cext_197 \$136 \$229 22.1768a
Cext_198 \$136 \$255 22.5483a
Cext_199 \$136 \$262 1.14995a
Cext_200 \$136 \$263 0.168207a
Cext_201 \$136 \$286 12.378a
Cext_202 \$136 \$287 578.386a
Cext_203 \$136 \$293 0.932704a
Cext_204 \$136 \$299 1.82883a
Cext_205 \$136 \$318 1.00013a
Cext_206 \$136 \$319 0.168207a
Cext_207 \$136 \$346 19.6365a
Cext_208 \$136 \$375 0.114033a
Cext_209 \$136 \$40 0.460633a
Cext_210 \$136 \$45 0.13685a
Cext_211 \$136 \$46 529.692a
Cext_212 \$136 \$71 117.917a
Cext_213 \$136 \$73 0.119911a
Cext_214 \$136 RST 90.1463a
Cext_215 \$136 Vctr|Vx 20.7935a
Cext_216 \$136 VDD 741.941a
Cext_217 \$136 Vref 5.12795f
Cext_218 \$136 VSS 236.099a
Cext_219 \$136 VSUBS 1.88493f
Cext_220 \$137 \$165 30.2471a
Cext_221 \$137 \$46 0.712711a
Cext_222 \$137 \$71 0.915371a
Cext_223 \$137 VDD 238.366a
Cext_224 \$137 VSUBS 30.4539a
Cext_225 \$138 \$139 862.212a
Cext_226 \$138 \$140 18.2166a
Cext_227 \$138 \$164 0.862943a
Cext_228 \$138 \$165 1.03186a
Cext_229 \$138 \$167 7.88112a
Cext_230 \$138 \$168 18.6588a
Cext_231 \$138 \$172 0.167938a
Cext_232 \$138 \$197 35.4785a
Cext_233 \$138 \$201 0.254046a
Cext_234 \$138 \$46 20.3058a
Cext_235 \$138 \$71 0.915371a
Cext_236 \$138 \$73 4.86902a
Cext_237 \$138 \$76 0.865932a
Cext_238 \$138 VDD 476.063a
Cext_239 \$138 Vref 8.1416a
Cext_240 \$138 VSS 310.813a
Cext_241 \$138 VSUBS 505.195a
Cext_242 \$139 \$140 4.39311a
Cext_243 \$139 \$164 0.588839a
Cext_244 \$139 \$165 1.6378a
Cext_245 \$139 \$167 12.6372a
Cext_246 \$139 \$168 49.7752a
Cext_247 \$139 \$198 74.5299a
Cext_248 \$139 \$199 0.401837a
Cext_249 \$139 \$200 0.443406a
Cext_250 \$139 \$201 0.110852a
Cext_251 \$139 \$46 19.7997a
Cext_252 \$139 \$71 0.379159a
Cext_253 \$139 \$74 8.85402a
Cext_254 \$139 Vctr|Vx 0.249803a
Cext_255 \$139 VDD 380.424a
Cext_256 \$139 Vref 0.289989a
Cext_257 \$139 VSS 262.635a
Cext_258 \$139 VSUBS 429.165a
Cext_259 \$14 RST|Ven 1.41118a
Cext_260 \$14 VDD 519.152a
Cext_261 \$14 Vout|vCMP 497.246a
Cext_262 \$14 VOUT|Vin 548.491a
Cext_263 \$14 VSS 363.249a
Cext_264 \$14 VSUBS 770.94a
Cext_265 \$140 \$177 1.37487a
Cext_266 \$140 \$202 31.403a
Cext_267 \$140 \$46 1.40382a
Cext_268 \$140 \$77 18.4185a
Cext_269 \$140 \$78 1.70191a
Cext_270 \$140 VDD 565.822a
Cext_271 \$140 VOUT|Vin 0.877361a
Cext_272 \$140 Vref 0.399745a
Cext_273 \$140 VSS 356.456a
Cext_274 \$140 VSUBS 1.13454f
Cext_275 \$164 \$165 936.178a
Cext_276 \$164 \$166 33.0911a
Cext_277 \$164 \$176 102.304a
Cext_278 \$164 \$177 0.135648a
Cext_279 \$164 \$195 579.005a
Cext_280 \$164 \$197 666.227a
Cext_281 \$164 \$198 843.516a
Cext_282 \$164 \$199 21.2936a
Cext_283 \$164 \$200 396.242a
Cext_284 \$164 \$202 9.50349a
Cext_285 \$164 \$223 478.745a
Cext_286 \$164 \$224 31.4666a
Cext_287 \$164 \$228 211.684a
Cext_288 \$164 \$229 12.4919a
Cext_289 \$164 \$230 29.0382a
Cext_290 \$164 \$231 2.25158a
Cext_291 \$164 \$255 0.666059a
Cext_292 \$164 \$256 0.124398a
Cext_293 \$164 \$257 0.865932a
Cext_294 \$164 \$261 0.666059a
Cext_295 \$164 \$262 0.661425a
Cext_296 \$164 \$263 0.379159a
Cext_297 \$164 \$286 2.40931a
Cext_298 \$164 \$287 0.982648a
Cext_299 \$164 \$46 252.342a
Cext_300 \$164 \$71 158.727a
Cext_301 \$164 RST 147.266a
Cext_302 \$164 Vctr|Vx 230.893a
Cext_303 \$164 VDD 579.932a
Cext_304 \$164 Vref 57.169a
Cext_305 \$164 VSS 283.7a
Cext_306 \$164 VSUBS 1.40265f
Cext_307 \$165 \$172 33.0911a
Cext_308 \$165 \$195 6.75853a
Cext_309 \$165 \$196 102.284a
Cext_310 \$165 \$197 220.158a
Cext_311 \$165 \$198 269.069a
Cext_312 \$165 \$199 9.4977a
Cext_313 \$165 \$200 13.8104a
Cext_314 \$165 \$223 15.5149a
Cext_315 \$165 \$224 293.471a
Cext_316 \$165 \$229 209.568a
Cext_317 \$165 \$231 19.5394a
Cext_318 \$165 \$263 0.497612a
Cext_319 \$165 \$46 44.0297a
Cext_320 \$165 \$71 1.15203a
Cext_321 \$165 RST 748.172a
Cext_322 \$165 Vctr|Vx 6.33782a
Cext_323 \$165 VDD 567.094a
Cext_324 \$165 Vref 248.071a
Cext_325 \$165 VSS 276.35a
Cext_326 \$165 VSUBS 1.37191f
Cext_327 \$166 \$195 0.7041a
Cext_328 \$166 \$223 0.63626a
Cext_329 \$166 Vctr|Vx 10.097a
Cext_330 \$166 Vref 0.408958a
Cext_331 \$166 VSS 129.572a
Cext_332 \$166 VSUBS 16.1208a
Cext_333 \$167 \$198 0.401837a
Cext_334 \$167 \$46 0.393105a
Cext_335 \$167 VSS 120.012a
Cext_336 \$167 VSUBS 15.4998a
Cext_337 \$168 \$197 0.254046a
Cext_338 \$168 \$198 0.110852a
Cext_339 \$168 \$46 0.134203a
Cext_340 \$168 VSS 136.977a
Cext_341 \$168 VSUBS 14.2823a
Cext_342 \$172 \$224 0.63626a
Cext_343 \$172 Vref 10.2115a
Cext_344 \$172 VSS 130.507a
Cext_345 \$172 VSUBS 16.1208a
Cext_346 \$176 \$195 1.82883a
Cext_347 \$176 \$223 22.0172a
Cext_348 \$176 RST 0.143514a
Cext_349 \$176 Vctr|Vx 10.9221a
Cext_350 \$176 Vref 0.705456a
Cext_351 \$176 VSS 129.572a
Cext_352 \$176 VSUBS 16.1208a
Cext_353 \$177 \$197 1.38144a
Cext_354 \$177 \$198 1.86333a
Cext_355 \$177 \$200 10.6747a
Cext_356 \$177 \$202 464.448a
Cext_357 \$177 \$259 1.70191a
Cext_358 \$177 \$260 36.2613a
Cext_359 \$177 \$46 0.22596a
Cext_360 \$177 VDD 650.51a
Cext_361 \$177 VOUT|Vin 134.883a
Cext_362 \$177 VSS 803.505a
Cext_363 \$177 VSUBS 575.99a
Cext_364 \$195 \$223 677.94a
Cext_365 \$195 \$224 9.326a
Cext_366 \$195 \$228 23.943a
Cext_367 \$195 \$261 22.9598a
Cext_368 \$195 \$286 460.784a
Cext_369 \$195 \$287 30.8313a
Cext_370 \$195 \$292 0.932704a
Cext_371 \$195 \$298 1.82883a
Cext_372 \$195 \$345 19.6365a
Cext_373 \$195 \$375 0.114033a
Cext_374 \$195 \$46 1.50101a
Cext_375 \$195 \$71 240.631a
Cext_376 \$195 RST 158.637a
Cext_377 \$195 Vctr|Vx 4.12464f
Cext_378 \$195 VDD 876.789a
Cext_379 \$195 Vref 21.6157a
Cext_380 \$195 VSS 209.564a
Cext_381 \$195 VSUBS 1.84809f
Cext_382 \$196 \$197 0.100763a
Cext_383 \$196 \$224 22.0172a
Cext_384 \$196 RST 0.381393a
Cext_385 \$196 Vref 10.508a
Cext_386 \$196 VSS 130.507a
Cext_387 \$196 VSUBS 16.1208a
Cext_388 \$197 \$198 862.196a
Cext_389 \$197 \$199 7.88112a
Cext_390 \$197 \$200 234.571a
Cext_391 \$197 \$201 18.6588a
Cext_392 \$197 \$202 18.2725a
Cext_393 \$197 \$223 0.92314a
Cext_394 \$197 \$224 0.625346a
Cext_395 \$197 \$230 19.5335a
Cext_396 \$197 \$257 0.865932a
Cext_397 \$197 \$262 4.86902a
Cext_398 \$197 \$46 20.5221a
Cext_399 \$197 RST 1.1356a
Cext_400 \$197 Vctr|Vx 0.125713a
Cext_401 \$197 VDD 473.295a
Cext_402 \$197 Vref 8.00302a
Cext_403 \$197 VSS 310.708a
Cext_404 \$197 VSUBS 504.558a
Cext_405 \$198 \$199 12.6372a
Cext_406 \$198 \$200 359.164a
Cext_407 \$198 \$201 49.8511a
Cext_408 \$198 \$202 4.39311a
Cext_409 \$198 \$223 0.379159a
Cext_410 \$198 \$224 0.497612a
Cext_411 \$198 \$230 3.56119a
Cext_412 \$198 \$231 57.2085a
Cext_413 \$198 \$256 0.233118a
Cext_414 \$198 \$258 0.184706a
Cext_415 \$198 \$263 8.9556a
Cext_416 \$198 \$46 18.4341a
Cext_417 \$198 RST 0.424964a
Cext_418 \$198 VDD 378.428a
Cext_419 \$198 Vref 0.34858a
Cext_420 \$198 VSS 262.894a
Cext_421 \$198 VSUBS 430.969a
Cext_422 \$199 \$200 98.0717a
Cext_423 \$199 \$231 0.185029a
Cext_424 \$199 \$46 0.393105a
Cext_425 \$199 VSS 120.012a
Cext_426 \$199 VSUBS 15.4998a
Cext_427 \$200 \$201 98.0717a
Cext_428 \$200 \$202 201.739a
Cext_429 \$200 \$223 0.865932a
Cext_430 \$200 \$224 0.235857a
Cext_431 \$200 \$230 209.993a
Cext_432 \$200 \$231 198.848a
Cext_433 \$200 \$257 20.202a
Cext_434 \$200 \$258 0.482027a
Cext_435 \$200 \$262 0.865932a
Cext_436 \$200 \$46 1.47105a
Cext_437 \$200 VDD 90.4793a
Cext_438 \$200 VSS 82.0775a
Cext_439 \$200 VSUBS 562.905a
Cext_440 \$201 \$230 0.185029a
Cext_441 \$201 \$46 0.134203a
Cext_442 \$201 VSS 136.977a
Cext_443 \$201 VSUBS 14.2823a
Cext_444 \$202 \$259 18.4185a
Cext_445 \$202 \$260 1.70191a
Cext_446 \$202 \$46 0.903861a
Cext_447 \$202 VDD 564.796a
Cext_448 \$202 VOUT|Vin 0.877361a
Cext_449 \$202 VSS 356.449a
Cext_450 \$202 VSUBS 1.13382f
Cext_451 \$223 \$224 671.476a
Cext_452 \$223 \$228 42.8053a
Cext_453 \$223 \$229 0.568736a
Cext_454 \$223 \$231 0.124398a
Cext_455 \$223 \$255 14.0621a
Cext_456 \$223 \$256 2.01947a
Cext_457 \$223 \$257 397.112a
Cext_458 \$223 \$258 29.0752a
Cext_459 \$223 \$259 9.40169a
Cext_460 \$223 \$260 0.102136a
Cext_461 \$223 \$261 215.409a
Cext_462 \$223 \$262 703.217a
Cext_463 \$223 \$263 831.371a
Cext_464 \$223 \$286 197.121a
Cext_465 \$223 \$287 7.12467a
Cext_466 \$223 \$292 98.0717a
Cext_467 \$223 \$294 19.9641a
Cext_468 \$223 \$318 1.79487a
Cext_469 \$223 \$319 0.588839a
Cext_470 \$223 \$46 396.791a
Cext_471 \$223 \$71 775.636a
Cext_472 \$223 RST 90.0461a
Cext_473 \$223 Vctr|Vx 221.625a
Cext_474 \$223 VDD 677.332a
Cext_475 \$223 Vref 30.9415a
Cext_476 \$223 VSS 288.828a
Cext_477 \$223 VSUBS 1.46943f
Cext_478 \$224 \$229 35.7234a
Cext_479 \$224 \$255 208.701a
Cext_480 \$224 \$256 19.4797a
Cext_481 \$224 \$257 13.8131a
Cext_482 \$224 \$261 0.160617a
Cext_483 \$224 \$262 211.777a
Cext_484 \$224 \$263 269.01a
Cext_485 \$224 \$286 9.23131a
Cext_486 \$224 \$287 250.261a
Cext_487 \$224 \$293 98.0717a
Cext_488 \$224 \$294 9.43492a
Cext_489 \$224 \$319 0.498248a
Cext_490 \$224 \$46 43.3827a
Cext_491 \$224 RST 1.15288f
Cext_492 \$224 Vctr|Vx 5.85893a
Cext_493 \$224 VDD 577.268a
Cext_494 \$224 Vref 209.098a
Cext_495 \$224 VSS 267.446a
Cext_496 \$224 VSUBS 1.3505f
Cext_497 \$228 \$286 0.627025a
Cext_498 \$228 Vctr|Vx 0.979531a
Cext_499 \$228 VDD 235.182a
Cext_500 \$228 VSUBS 30.1198a
Cext_501 \$229 \$287 0.627025a
Cext_502 \$229 VDD 236.601a
Cext_503 \$229 Vref 0.296081a
Cext_504 \$229 VSUBS 30.1683a
Cext_505 \$230 \$257 0.482027a
Cext_506 \$230 \$263 0.184706a
Cext_507 \$230 \$46 0.561213a
Cext_508 \$230 VDD 252.053a
Cext_509 \$230 VSUBS 30.0987a
Cext_510 \$231 \$263 0.233118a
Cext_511 \$231 \$46 0.982764a
Cext_512 \$231 VDD 216.858a
Cext_513 \$231 VSUBS 28.8423a
Cext_514 \$255 \$287 30.3047a
Cext_515 \$255 VDD 238.366a
Cext_516 \$255 VSUBS 30.3255a
Cext_517 \$256 \$257 200.074a
Cext_518 \$256 \$263 57.3699a
Cext_519 \$256 \$294 0.185029a
Cext_520 \$256 \$46 1.07385a
Cext_521 \$256 VDD 218.084a
Cext_522 \$256 VSUBS 28.6926a
Cext_523 \$257 \$258 210.728a
Cext_524 \$257 \$259 200.929a
Cext_525 \$257 \$260 10.6747a
Cext_526 \$257 \$262 238.475a
Cext_527 \$257 \$263 347.847a
Cext_528 \$257 \$287 0.310351a
Cext_529 \$257 \$291 98.0717a
Cext_530 \$257 \$294 98.0717a
Cext_531 \$257 \$319 0.443406a
Cext_532 \$257 \$320 10.7813a
Cext_533 \$257 \$46 1.62319a
Cext_534 \$257 VDD 90.6107a
Cext_535 \$257 VSS 81.6877a
Cext_536 \$257 VSUBS 564.358a
Cext_537 \$258 \$262 19.6949a
Cext_538 \$258 \$263 3.56119a
Cext_539 \$258 \$291 0.185029a
Cext_540 \$258 \$46 0.683216a
Cext_541 \$258 VDD 252.721a
Cext_542 \$258 VSUBS 29.9643a
Cext_543 \$259 \$260 464.26a
Cext_544 \$259 \$262 18.3987a
Cext_545 \$259 \$263 4.28985a
Cext_546 \$259 \$321 31.403a
Cext_547 \$259 \$322 1.37487a
Cext_548 \$259 \$46 0.903861a
Cext_549 \$259 VDD 566.091a
Cext_550 \$259 VOUT|Vin 0.877361a
Cext_551 \$259 VSS 356.314a
Cext_552 \$259 VSUBS 1.13333f
Cext_553 \$260 \$262 1.38144a
Cext_554 \$260 \$263 1.86333a
Cext_555 \$260 \$321 1.37487a
Cext_556 \$260 \$322 28.7587a
Cext_557 \$260 \$46 0.22596a
Cext_558 \$260 VDD 650.51a
Cext_559 \$260 VOUT|Vin 134.851a
Cext_560 \$260 VSS 803.386a
Cext_561 \$260 VSUBS 575.932a
Cext_562 \$261 \$286 32.3584a
Cext_563 \$261 Vctr|Vx 0.855605a
Cext_564 \$261 VDD 236.496a
Cext_565 \$261 VSUBS 30.1972a
Cext_566 \$262 \$263 823.613a
Cext_567 \$262 \$286 0.862943a
Cext_568 \$262 \$287 1.2505a
Cext_569 \$262 \$291 18.623a
Cext_570 \$262 \$293 0.167938a
Cext_571 \$262 \$294 7.76043a
Cext_572 \$262 \$301 0.254046a
Cext_573 \$262 \$318 35.5208a
Cext_574 \$262 \$46 19.8918a
Cext_575 \$262 VDD 476.363a
Cext_576 \$262 Vref 7.73395a
Cext_577 \$262 VSS 310.49a
Cext_578 \$262 VSUBS 505.983a
Cext_579 \$263 \$286 0.588839a
Cext_580 \$263 \$287 0.430305a
Cext_581 \$263 \$291 49.6304a
Cext_582 \$263 \$294 12.5225a
Cext_583 \$263 \$300 0.290985a
Cext_584 \$263 \$301 0.110852a
Cext_585 \$263 \$319 73.7465a
Cext_586 \$263 \$46 18.7182a
Cext_587 \$263 Vctr|Vx 0.499606a
Cext_588 \$263 VDD 381.039a
Cext_589 \$263 Vref 0.34858a
Cext_590 \$263 VSS 262.052a
Cext_591 \$263 VSUBS 428.067a
Cext_592 \$286 \$287 1.02271f
Cext_593 \$286 \$292 32.3103a
Cext_594 \$286 \$298 104.553a
Cext_595 \$286 \$300 20.1255a
Cext_596 \$286 \$318 699.529a
Cext_597 \$286 \$319 796.923a
Cext_598 \$286 \$320 400.634a
Cext_599 \$286 \$321 9.10429a
Cext_600 \$286 \$345 213.041a
Cext_601 \$286 \$346 12.8839a
Cext_602 \$286 \$347 2.10349a
Cext_603 \$286 \$348 28.7245a
Cext_604 \$286 \$375 0.207298a
Cext_605 \$286 \$378 0.158528a
Cext_606 \$286 \$46 88.3057a
Cext_607 \$286 \$71 348.572a
Cext_608 \$286 RST 122.763a
Cext_609 \$286 Vctr|Vx 230.14a
Cext_610 \$286 VDD 699.463a
Cext_611 \$286 Vref 10.9844a
Cext_612 \$286 VSS 286.612a
Cext_613 \$286 VSUBS 1.4889f
Cext_614 \$287 \$293 32.2447a
Cext_615 \$287 \$298 0.173497a
Cext_616 \$287 \$299 104.503a
Cext_617 \$287 \$300 9.4977a
Cext_618 \$287 \$318 218.889a
Cext_619 \$287 \$319 269.15a
Cext_620 \$287 \$320 8.96215a
Cext_621 \$287 \$345 0.645969a
Cext_622 \$287 \$346 206.127a
Cext_623 \$287 \$347 19.5839a
Cext_624 \$287 \$375 0.115607a
Cext_625 \$287 \$46 274.624a
Cext_626 \$287 \$71 4.00911a
Cext_627 \$287 RST 814.97a
Cext_628 \$287 Vctr|Vx 2.46644a
Cext_629 \$287 VDD 585.768a
Cext_630 \$287 Vref 223.789a
Cext_631 \$287 VSS 277.057a
Cext_632 \$287 VSUBS 1.38771f
Cext_633 \$291 \$318 0.254046a
Cext_634 \$291 \$319 0.110852a
Cext_635 \$291 \$46 0.134203a
Cext_636 \$291 VSS 136.623a
Cext_637 \$291 VSUBS 14.2567a
Cext_638 \$292 \$71 0.277447a
Cext_639 \$292 Vctr|Vx 9.73979a
Cext_640 \$292 VSS 129.572a
Cext_641 \$292 VSUBS 16.1208a
Cext_642 \$293 \$46 0.282818a
Cext_643 \$293 Vref 9.73979a
Cext_644 \$293 VSS 130.507a
Cext_645 \$293 VSUBS 16.0696a
Cext_646 \$294 \$319 0.401837a
Cext_647 \$294 \$46 0.393105a
Cext_648 \$294 VSS 119.304a
Cext_649 \$294 VSUBS 15.4486a
Cext_650 \$298 \$71 19.6569a
Cext_651 \$298 RST 0.217928a
Cext_652 \$298 Vctr|Vx 11.1189a
Cext_653 \$298 VSS 129.572a
Cext_654 \$298 VSUBS 15.9496a
Cext_655 \$299 \$318 0.125954a
Cext_656 \$299 \$46 19.7337a
Cext_657 \$299 Vref 11.0715a
Cext_658 \$299 VSS 130.507a
Cext_659 \$299 VSUBS 16.1208a
Cext_660 \$3 \$39 196.143a
Cext_661 \$3 \$46 0.118209a
Cext_662 \$3 RST|Ven 65.0541a
Cext_663 \$3 VDD 215.259a
Cext_664 \$3 Vout|vCMP 19.7307a
Cext_665 \$3 VSUBS 29.2171a
Cext_666 \$300 \$318 7.88112a
Cext_667 \$300 \$319 12.4422a
Cext_668 \$300 \$320 98.0717a
Cext_669 \$300 \$347 0.185029a
Cext_670 \$300 \$46 0.393105a
Cext_671 \$300 VSS 119.304a
Cext_672 \$300 VSUBS 15.294a
Cext_673 \$301 \$318 18.6588a
Cext_674 \$301 \$319 49.1662a
Cext_675 \$301 \$320 98.0717a
Cext_676 \$301 \$348 0.185029a
Cext_677 \$301 \$46 0.134203a
Cext_678 \$301 VSS 136.623a
Cext_679 \$301 VSUBS 14.0938a
Cext_680 \$318 \$319 794.591a
Cext_681 \$318 \$320 238.579a
Cext_682 \$318 \$321 18.3893a
Cext_683 \$318 \$322 1.38144a
Cext_684 \$318 \$348 19.6769a
Cext_685 \$318 \$46 15.9199a
Cext_686 \$318 VDD 479.405a
Cext_687 \$318 Vref 7.65962a
Cext_688 \$318 VSS 309.862a
Cext_689 \$318 VSUBS 508.324a
Cext_690 \$319 \$320 346.005a
Cext_691 \$319 \$321 4.24958a
Cext_692 \$319 \$322 1.86333a
Cext_693 \$319 \$347 56.3867a
Cext_694 \$319 \$348 3.47752a
Cext_695 \$319 \$375 0.0905873a
Cext_696 \$319 \$381 0.109273a
Cext_697 \$319 \$46 16.399a
Cext_698 \$319 RST 0.106684a
Cext_699 \$319 VDD 389.806a
Cext_700 \$319 Vref 0.34858a
Cext_701 \$319 VSS 260.998a
Cext_702 \$319 VSUBS 427.609a
Cext_703 \$320 \$321 200.884a
Cext_704 \$320 \$322 10.6747a
Cext_705 \$320 \$347 199.806a
Cext_706 \$320 \$348 210.852a
Cext_707 \$320 \$46 0.691284a
Cext_708 \$320 RST 0.23941a
Cext_709 \$320 VDD 119.67a
Cext_710 \$320 VSS 81.5662a
Cext_711 \$320 VSUBS 564.452a
Cext_712 \$321 \$322 462.548a
Cext_713 \$321 VDD 584.783a
Cext_714 \$321 VOUT|Vin 0.877361a
Cext_715 \$321 VSS 356.107a
Cext_716 \$321 VSUBS 1.13852f
Cext_717 \$322 VDD 708.281a
Cext_718 \$322 VOUT|Vin 134.851a
Cext_719 \$322 VSS 799.682a
Cext_720 \$322 VSUBS 558.649a
Cext_721 \$345 \$71 30.0399a
Cext_722 \$345 Vctr|Vx 0.444845a
Cext_723 \$345 VDD 237.6a
Cext_724 \$345 VSUBS 30.6679a
Cext_725 \$346 \$46 29.132a
Cext_726 \$346 Vctr|Vx 0.186523a
Cext_727 \$346 VDD 239.971a
Cext_728 \$346 VSUBS 30.6168a
Cext_729 \$347 VDD 220.257a
Cext_730 \$347 VSUBS 29.0605a
Cext_731 \$348 VDD 254.701a
Cext_732 \$348 VSUBS 30.5044a
Cext_733 \$375 \$376 33.2931a
Cext_734 \$375 \$377 33.2659a
Cext_735 \$375 \$378 79.6363a
Cext_736 \$375 \$381 37.5904a
Cext_737 \$375 Vctr|Vx 61.4649a
Cext_738 \$375 VDD 1.3934f
Cext_739 \$375 VSUBS 399.241a
Cext_740 \$376 \$377 143.934a
Cext_741 \$376 RST 0.169393a
Cext_742 \$376 Vctr|Vx 2.14536a
Cext_743 \$376 VDD 133.342a
Cext_744 \$376 VSUBS 174.215a
Cext_745 \$377 \$381 1.47372a
Cext_746 \$377 \$46 0.080619a
Cext_747 \$377 Vctr|Vx 0.333208a
Cext_748 \$377 VDD 130.382a
Cext_749 \$377 VSUBS 174.075a
Cext_750 \$378 \$379 33.3003a
Cext_751 \$378 \$380 33.368a
Cext_752 \$378 \$381 37.5033a
Cext_753 \$378 VDD 1.3816f
Cext_754 \$378 VOUT|Vin 68.0221a
Cext_755 \$378 VSS 1.02912a
Cext_756 \$378 VSUBS 401.414a
Cext_757 \$379 \$380 154.565a
Cext_758 \$379 \$381 1.47372a
Cext_759 \$379 VDD 124.636a
Cext_760 \$379 VOUT|Vin 0.417649a
Cext_761 \$379 VSUBS 176.074a
Cext_762 \$380 VDD 128.233a
Cext_763 \$380 VOUT|Vin 2.2395a
Cext_764 \$380 VSUBS 174.171a
Cext_765 \$381 VDD 97.419a
Cext_766 \$381 VSUBS 191.535a
Cext_767 \$39 \$40 13.2154a
Cext_768 \$39 \$46 0.99904a
Cext_769 \$39 \$7 7.07135a
Cext_770 \$39 \$8 186.172a
Cext_771 \$39 \$9 0.0747556a
Cext_772 \$39 RST|Ven 294.999a
Cext_773 \$39 RST 1.7835a
Cext_774 \$39 SPIKE 238.62a
Cext_775 \$39 Vctr|Vx 1.17988a
Cext_776 \$39 VDD 63.4984a
Cext_777 \$39 Vout|vCMP 548.774a
Cext_778 \$39 VSS 250.244a
Cext_779 \$39 VSUBS 447.591a
Cext_780 \$40 \$46 7.69379a
Cext_781 \$40 \$5 188.342a
Cext_782 \$40 \$6 0.83768a
Cext_783 \$40 \$71 0.691397a
Cext_784 \$40 \$73 1.1751a
Cext_785 \$40 \$9 5.01123a
Cext_786 \$40 RST|Ven 218.059a
Cext_787 \$40 RST 0.243708a
Cext_788 \$40 SPIKE 306.383a
Cext_789 \$40 VDD 521.881a
Cext_790 \$40 Vout|vCMP 322.387a
Cext_791 \$40 Vref 2.88346a
Cext_792 \$40 VSS 300.685a
Cext_793 \$40 VSUBS 1.05184f
Cext_794 \$43 \$6 97.383a
Cext_795 \$43 \$74 1.19022a
Cext_796 \$43 \$9 9.77118a
Cext_797 \$43 Vout|vCMP 52.3485a
Cext_798 \$43 VSS 119.44a
Cext_799 \$43 VSUBS 15.3638a
Cext_800 \$45 \$71 98.0717a
Cext_801 \$45 RST 12.1284a
Cext_802 \$45 SPIKE 0.26997a
Cext_803 \$45 Vctr|Vx 9.71291a
Cext_804 \$45 VSS 129.572a
Cext_805 \$45 VSUBS 15.9282a
Cext_806 \$46 \$6 1.96802a
Cext_807 \$46 \$71 1.06672f
Cext_808 \$46 \$72 99.1866a
Cext_809 \$46 \$73 229.165a
Cext_810 \$46 \$74 269.476a
Cext_811 \$46 \$75 9.4977a
Cext_812 \$46 \$76 15.057a
Cext_813 \$46 \$77 0.975584a
Cext_814 \$46 \$78 0.108068a
Cext_815 \$46 RST|Ven 1.43246a
Cext_816 \$46 RST 276.34a
Cext_817 \$46 SPIKE 9.17717a
Cext_818 \$46 Vctr|Vx 3.77113a
Cext_819 \$46 VDD 680.269a
Cext_820 \$46 Vout|vCMP 4.59306a
Cext_821 \$46 Vref 4.5106f
Cext_822 \$46 VSS 283.39a
Cext_823 \$46 VSUBS 1.61793f
Cext_824 \$47 \$73 18.6178a
Cext_825 \$47 \$74 50.6052a
Cext_826 \$47 \$76 98.0717a
Cext_827 \$47 Vout|vCMP 0.107373a
Cext_828 \$47 VSS 137.684a
Cext_829 \$47 VSUBS 14.299a
Cext_830 \$5 \$6 184.873a
Cext_831 \$5 \$71 1.70218a
Cext_832 \$5 \$73 1.16999a
Cext_833 \$5 \$74 1.72559a
Cext_834 \$5 \$9 23.1623a
Cext_835 \$5 RST|Ven 25.1581a
Cext_836 \$5 SPIKE 0.452442a
Cext_837 \$5 VDD 392.657a
Cext_838 \$5 Vout|vCMP 48.2118a
Cext_839 \$5 VSS 257.645a
Cext_840 \$5 VSUBS 533.71a
Cext_841 \$6 \$73 0.161751a
Cext_842 \$6 \$74 3.52853a
Cext_843 \$6 \$9 611.587a
Cext_844 \$6 RST|Ven 327.479a
Cext_845 \$6 SPIKE 0.27859a
Cext_846 \$6 VDD 510.757a
Cext_847 \$6 Vout|vCMP 163.24a
Cext_848 \$6 VSS 47.075a
Cext_849 \$6 VSUBS 448.276a
Cext_850 \$7 \$71 1.12141a
Cext_851 \$7 \$8 200.992a
Cext_852 \$7 RST|Ven 91.686a
Cext_853 \$7 RST 461.505a
Cext_854 \$7 SPIKE 128.511a
Cext_855 \$7 Vctr|Vx 0.786842a
Cext_856 \$7 VDD 520.39a
Cext_857 \$7 Vout|vCMP 0.520426a
Cext_858 \$7 VSS 289.603a
Cext_859 \$7 VSUBS 1.12944f
Cext_860 \$71 \$73 670.963a
Cext_861 \$71 \$74 852.299a
Cext_862 \$71 \$75 21.0101a
Cext_863 \$71 \$76 394.069a
Cext_864 \$71 \$77 9.59038a
Cext_865 \$71 \$78 0.289599a
Cext_866 \$71 \$9 2.36416a
Cext_867 \$71 RST 4.48453f
Cext_868 \$71 SPIKE 0.579435a
Cext_869 \$71 Vctr|Vx 184.184a
Cext_870 \$71 VDD 685.251a
Cext_871 \$71 Vout|vCMP 0.910804a
Cext_872 \$71 Vref 76.4529a
Cext_873 \$71 VSS 231.862a
Cext_874 \$71 VSUBS 1.62962f
Cext_875 \$72 \$73 0.167938a
Cext_876 \$72 RST 1.81141a
Cext_877 \$72 SPIKE 0.766966a
Cext_878 \$72 Vref 9.71291a
Cext_879 \$72 VSS 130.507a
Cext_880 \$72 VSUBS 15.9371a
Cext_881 \$73 \$74 855.685a
Cext_882 \$73 \$75 7.88112a
Cext_883 \$73 \$76 232.784a
Cext_884 \$73 \$77 18.0496a
Cext_885 \$73 \$78 1.38144a
Cext_886 \$73 RST 1.34233a
Cext_887 \$73 VDD 474.894a
Cext_888 \$73 Vout|vCMP 22.4496a
Cext_889 \$73 Vref 7.68672a
Cext_890 \$73 VSS 309.82a
Cext_891 \$73 VSUBS 514.307a
Cext_892 \$74 \$75 12.4674a
Cext_893 \$74 \$76 354.193a
Cext_894 \$74 \$77 4.39193a
Cext_895 \$74 \$78 1.86333a
Cext_896 \$74 \$9 1.42153a
Cext_897 \$74 RST 8.69071a
Cext_898 \$74 VDD 379.798a
Cext_899 \$74 Vout|vCMP 41.0229a
Cext_900 \$74 Vref 0.122407a
Cext_901 \$74 VSS 263.98a
Cext_902 \$74 VSUBS 439.185a
Cext_903 \$75 \$76 98.0717a
Cext_904 \$75 VSS 120.012a
Cext_905 \$75 VSUBS 15.4142a
Cext_906 \$76 \$77 200.325a
Cext_907 \$76 \$78 10.6747a
Cext_908 \$76 \$9 0.166316a
Cext_909 \$76 RST 0.831258a
Cext_910 \$76 VDD 90.2442a
Cext_911 \$76 Vout|vCMP 9.96803a
Cext_912 \$76 VSS 80.5939a
Cext_913 \$76 VSUBS 557.386a
Cext_914 \$77 \$78 461.063a
Cext_915 \$77 VDD 565.164a
Cext_916 \$77 Vout|vCMP 23.4769a
Cext_917 \$77 VOUT|Vin 0.334789a
Cext_918 \$77 VSS 356.254a
Cext_919 \$77 VSUBS 1.13376f
Cext_920 \$78 VDD 650.383a
Cext_921 \$78 Vout|vCMP 35.8571a
Cext_922 \$78 VOUT|Vin 133.907a
Cext_923 \$78 VSS 798.167a
Cext_924 \$78 VSUBS 565.003a
Cext_925 \$8 RST|Ven 39.3523a
Cext_926 \$8 RST 3.46398a
Cext_927 \$8 SPIKE 29.5963a
Cext_928 \$8 Vctr|Vx 0.492109a
Cext_929 \$8 VDD 427.465a
Cext_930 \$8 Vout|vCMP 38.5858a
Cext_931 \$8 VSS 275.428a
Cext_932 \$8 VSUBS 516.641a
Cext_933 \$9 RST|Ven 59.5139a
Cext_934 \$9 SPIKE 0.123586a
Cext_935 \$9 VDD 251.656a
Cext_936 \$9 Vout|vCMP 497.914a
Cext_937 \$9 VSS 85.8831a
Cext_938 \$9 VSUBS 371.953a
Cext_939 RST|Ven RST 781.781a
Cext_940 RST|Ven SPIKE 75.496a
Cext_941 RST|Ven VDD 243.841a
Cext_942 RST|Ven Vout|vCMP 458.86a
Cext_943 RST|Ven VOUT|Vin 0.453984a
Cext_944 RST|Ven VSS 21.128a
Cext_945 RST|Ven VSUBS 1.00786f
Cext_946 RST SPIKE 267.446a
Cext_947 RST Vctr|Vx 5.97605f
Cext_948 RST VDD 946.16a
Cext_949 RST Vout|vCMP 4.28649a
Cext_950 RST Vref 195.556a
Cext_951 RST VSS 921.952a
Cext_952 RST VSUBS 3.17138f
Cext_953 SPIKE Vctr|Vx 0.465718a
Cext_954 SPIKE VDD 629.899a
Cext_955 SPIKE Vout|vCMP 517.321a
Cext_956 SPIKE Vref 22.2355a
Cext_957 SPIKE VSS 534.601a
Cext_958 SPIKE VSUBS 476.63a
Cext_959 Vctr|Vx Vref 123.023a
Cext_960 VDD Vctr|Vx 166.827a
Cext_961 VDD Vout|vCMP 633.509a
Cext_962 VDD VOUT|Vin 5.47851f
Cext_963 VDD Vref 69.1152a
Cext_964 VDD VSS 3.97336f
Cext_965 VDD VSUBS 17.4547f
Cext_966 VOUT|Vin Vout|vCMP 73.9805a
Cext_967 VOUT|Vin VSS 2.50743f
Cext_968 VOUT|Vin VSUBS 3.75805f
Cext_969 VSS Vctr|Vx 399.964a
Cext_970 VSS Vout|vCMP 522.878a
Cext_971 VSS Vref 386.458a
Cext_972 VSS VSUBS 19.0361f
Cext_973 VSUBS Vctr|Vx 2.77019f
Cext_974 VSUBS Vout|vCMP 1.64236f
Cext_975 VSUBS Vref 1.60178f
.ENDS LIF_neuron
