* PEX produced on Sun Mar 22 05:07:16 PM CET 2026 using /foss/tools/sak/sak-pex.sh with m=2 and s=1
* NGSPICE file created from LIF_neuron.ext - technology: ihp-sg13g2

.subckt LIF_neuron VDD Vx MEM RST SPIKE VSS Vref COMP
X0 VSS VSS VSS rppd l=0.5u w=0.5u
X1 VSS a_2538_4709# a_2130_4709# VSS sg13_lv_nmos ad=0.34p pd=2.68u as=0.34p ps=2.68u w=1u l=0.13u
X2 a_3521_9195# a_3317_9195# VSS VSS sg13_lv_nmos ad=0.19p pd=1.38u as=0.34p ps=2.68u w=1u l=0.13u
X3 VDD a_1071_4709# a_1003_4745# VDD sg13_lv_pmos ad=0.38p pd=2.38u as=0.68p ps=4.68u w=2u l=0.13u
X4 VSS a_2769_4709# a_2538_4709# VSS sg13_lv_nmos ad=0.19p pd=1.38u as=0.34p ps=2.68u w=1u l=0.13u
X5 VSS a_2130_4709# SPIKE VSS sg13_lv_nmos ad=0.19p pd=1.38u as=0.34p ps=2.68u w=1u l=0.13u
X6 a_3521_6967# a_3317_6967# VSS VSS sg13_lv_nmos ad=0.34p pd=2.68u as=0.19p ps=1.38u w=1u l=0.13u
X7 VSS a_3545_4709# a_3207_4709# VSS sg13_lv_nmos ad=0.34p pd=2.68u as=0.34p ps=2.68u w=1u l=0.65u
X8 VSS VSS VSS rppd l=0.5u w=0.5u
X9 VSS VSS VSS rppd l=0.5u w=0.5u
X10 a_1369_6967# a_1267_8081# a_1267_6967# VDD sg13_lv_pmos ad=0.38p pd=2.38u as=0.38p ps=2.38u w=2u l=0.13u
X11 VDD VDD VSS rhigh l=0.96u w=0.5u
X12 VDD a_917_8508# a_1369_9195# VDD sg13_lv_pmos ad=0.68p pd=4.68u as=0.38p ps=2.38u w=2u l=0.13u
X13 a_3317_6967# a_2907_6967# VSS VSS sg13_lv_nmos ad=0.34p pd=2.68u as=0.34p ps=2.68u w=1u l=0.13u
X14 a_2907_6967# a_2584_6967# a_2805_6967# VDD sg13_lv_pmos ad=0.38p pd=2.38u as=0.38p ps=2.38u w=2u l=0.13u
X15 a_2907_10309# a_2584_10309# a_2805_10831# VDD sg13_lv_pmos ad=0.38p pd=2.38u as=0.38p ps=2.38u w=2u l=0.13u
X16 a_1369_10309# a_1267_5853# a_1267_10309# VSS sg13_lv_nmos ad=0.19p pd=1.38u as=0.19p ps=1.38u w=1u l=0.13u
X17 a_3009_9195# a_1267_9195# a_2907_9195# VDD sg13_lv_pmos ad=0.38p pd=2.38u as=0.38p ps=2.38u w=2u l=0.13u
X18 a_1839_8081# VDD VDD VDD sg13_lv_pmos ad=0.38p pd=2.38u as=0.68p ps=4.68u w=2u l=0.13u
X19 a_1267_5853# a_1003_4745# VSS VSS sg13_lv_nmos ad=0.19p pd=1.38u as=0.34p ps=2.68u w=1u l=0.13u
X20 a_3521_8081# MEM VSS rppd l=0.5u w=0.5u
X21 a_1369_8081# a_1267_9195# a_1267_8081# VSS sg13_lv_nmos ad=0.19p pd=1.38u as=0.19p ps=1.38u w=1u l=0.13u
X22 VDD COMP a_4221_4709# VDD sg13_lv_pmos ad=0.68p pd=4.68u as=0.68p ps=4.68u w=2u l=0.65u
X23 VDD a_3883_4709# a_3545_4709# VDD sg13_lv_pmos ad=0.68p pd=4.68u as=0.68p ps=4.68u w=2u l=0.65u
X24 a_2907_8081# a_1267_8081# a_2805_8081# VSS sg13_lv_nmos ad=0.19p pd=1.38u as=0.19p ps=1.38u w=1u l=0.13u
X25 VSS RST a_1692_4709# VSS sg13_lv_nmos ad=0.34p pd=2.68u as=0.19p ps=1.38u w=1u l=0.13u
X26 VSS VSS VSS rppd l=0.5u w=0.5u
X27 VSS a_4828_5366# COMP VSS sg13_lv_nmos ad=0.19p pd=1.38u as=0.19p ps=1.38u w=1u l=0.13u
X28 a_3521_10309# a_3317_10309# VSS VSS sg13_lv_nmos ad=0.19p pd=1.38u as=0.34p ps=2.68u w=1u l=0.13u
X29 a_3521_6967# a_3317_6967# VDD VDD sg13_lv_pmos ad=0.68p pd=4.68u as=0.38p ps=2.38u w=2u l=0.13u
X30 VSS VSS VSS rppd l=0.5u w=0.5u
X31 a_2584_10309# a_1267_10309# VSS VSS sg13_lv_nmos ad=0.34p pd=2.68u as=0.34p ps=2.68u w=1u l=0.13u
X32 VDD a_2538_4709# a_2130_4709# VDD sg13_lv_pmos ad=0.68p pd=4.68u as=0.68p ps=4.68u w=2u l=0.13u
X33 VSS VSS VSS rppd l=0.5u w=0.5u
X34 a_3317_6967# a_2907_6967# VDD VDD sg13_lv_pmos ad=0.68p pd=4.68u as=0.68p ps=4.68u w=2u l=0.13u
X35 VSS a_3317_5853# a_3521_5853# VSS sg13_lv_nmos ad=0.19p pd=1.38u as=0.19p ps=1.38u w=1u l=0.13u
X36 a_1839_9195# VSS VSS VSS sg13_lv_nmos ad=0.19p pd=1.38u as=0.34p ps=2.68u w=1u l=0.13u
X37 a_3521_8081# a_3317_8081# VSS VSS sg13_lv_nmos ad=0.34p pd=2.68u as=0.19p ps=1.38u w=1u l=0.13u
X38 VDD a_2130_4709# SPIKE VDD sg13_lv_pmos ad=0.38p pd=2.38u as=0.68p ps=4.68u w=2u l=0.13u
X39 a_1267_8081# VDD VDD VDD sg13_lv_pmos ad=0.38p pd=2.38u as=0.68p ps=4.68u w=2u l=0.13u
X40 a_2805_10309# a_1839_10309# VSS VSS sg13_lv_nmos ad=0.19p pd=1.38u as=0.34p ps=2.68u w=1u l=0.13u
X41 a_1003_4745# a_1071_4709# VSS VSS sg13_lv_nmos ad=0.19p pd=1.38u as=0.19p ps=1.38u w=1u l=0.13u
X42 VSS a_2380_5853# a_3009_5853# VSS sg13_lv_nmos ad=0.34p pd=2.68u as=0.19p ps=1.38u w=1u l=0.13u
X43 a_3317_8081# a_2907_8081# VSS VSS sg13_lv_nmos ad=0.34p pd=2.68u as=0.34p ps=2.68u w=1u l=0.13u
X44 a_2584_5853# a_1267_5853# VSS VSS sg13_lv_nmos ad=0.34p pd=2.68u as=0.34p ps=2.68u w=1u l=0.13u
X45 VSS VSS VSS rppd l=0.5u w=0.5u
X46 VDD a_917_8508# a_1369_6375# VDD sg13_lv_pmos ad=0.68p pd=4.68u as=0.38p ps=2.38u w=2u l=0.13u
X47 VSS VSS VSS rppd l=0.5u w=0.5u
X48 a_2380_9195# a_1839_9195# VDD VDD sg13_lv_pmos ad=0.68p pd=4.68u as=0.68p ps=4.68u w=2u l=0.13u
X49 a_3009_6375# a_1267_5853# a_2907_5853# VDD sg13_lv_pmos ad=0.38p pd=2.38u as=0.38p ps=2.38u w=2u l=0.13u
X50 VSS VSS VSS rppd l=0.5u w=0.5u
X51 a_1839_10309# VDD VDD VDD sg13_lv_pmos ad=0.38p pd=2.38u as=0.68p ps=4.68u w=2u l=0.13u
X52 VSS MEM a_4828_5366# VSS sg13_lv_nmos ad=0.34p pd=2.68u as=0.19p ps=1.38u w=1u l=0.13u
X53 VSS VSS VSS rppd l=0.5u w=0.5u
X54 VDD a_3317_8081# a_3521_8081# VDD sg13_lv_pmos ad=0.38p pd=2.38u as=0.38p ps=2.38u w=2u l=0.13u
X55 a_1692_4709# RST a_1820_4745# VDD sg13_lv_pmos ad=0.68p pd=4.68u as=0.38p ps=2.38u w=2u l=0.13u
X56 a_1267_9195# VSS VSS VSS sg13_lv_nmos ad=0.19p pd=1.38u as=0.34p ps=2.68u w=1u l=0.13u
X57 VSS VSS VSS rppd l=0.5u w=0.5u
X58 a_2907_10309# a_1267_10309# a_2805_10309# VSS sg13_lv_nmos ad=0.19p pd=1.38u as=0.19p ps=1.38u w=1u l=0.13u
X59 VSS VSS VSS rppd l=0.5u w=0.5u
X60 VDD a_917_8508# a_1369_10831# VDD sg13_lv_pmos ad=0.68p pd=4.68u as=0.38p ps=2.38u w=2u l=0.13u
X61 VSS VX a_1369_7689# VSS sg13_lv_nmos ad=0.34p pd=2.68u as=0.19p ps=1.38u w=1u l=0.13u
X62 VDD a_2380_8081# a_3009_8603# VDD sg13_lv_pmos ad=0.68p pd=4.68u as=0.38p ps=2.38u w=2u l=0.13u
X63 VDD COMP a_2769_4709# VDD sg13_lv_pmos ad=0.68p pd=4.68u as=0.38p ps=2.38u w=2u l=0.13u
X64 a_2584_8081# a_1267_8081# VDD VDD sg13_lv_pmos ad=0.68p pd=4.68u as=0.68p ps=4.68u w=2u l=0.13u
X65 a_3009_7689# a_2584_6967# a_2907_6967# VSS sg13_lv_nmos ad=0.19p pd=1.38u as=0.19p ps=1.38u w=1u l=0.13u
X66 VDD VDD VSS rhigh l=0.96u w=0.5u
X67 a_3521_8081# MEM VSS rppd l=0.5u w=0.5u
X68 a_1941_5853# a_1839_6967# a_1839_5853# VSS sg13_lv_nmos ad=0.19p pd=1.38u as=0.19p ps=1.38u w=1u l=0.13u
X69 VSS a_3317_9195# a_3521_9195# VSS sg13_lv_nmos ad=0.19p pd=1.38u as=0.19p ps=1.38u w=1u l=0.13u
X70 a_917_8508# a_917_8508# VDD VDD sg13_lv_pmos ad=0.68p pd=4.68u as=0.68p ps=4.68u w=2u l=0.13u
X71 a_1003_4745# a_1071_4709# VDD VDD sg13_lv_pmos ad=0.38p pd=2.38u as=0.38p ps=2.38u w=2u l=0.13u
X72 SPIKE a_2130_4709# VSS VSS sg13_lv_nmos ad=0.19p pd=1.38u as=0.19p ps=1.38u w=1u l=0.13u
X73 a_2380_5853# a_1839_5853# VDD VDD sg13_lv_pmos ad=0.68p pd=4.68u as=0.68p ps=4.68u w=2u l=0.13u
X74 VDD a_3317_10309# a_3521_10309# VDD sg13_lv_pmos ad=0.38p pd=2.38u as=0.38p ps=2.38u w=2u l=0.13u
X75 a_2584_9195# a_1267_9195# VSS VSS sg13_lv_nmos ad=0.34p pd=2.68u as=0.34p ps=2.68u w=1u l=0.13u
X76 VSS a_2380_9195# a_3009_9917# VSS sg13_lv_nmos ad=0.34p pd=2.68u as=0.19p ps=1.38u w=1u l=0.13u
X77 VSS VSS VSS rppd l=0.5u w=0.5u
X78 VSS VSS VSS rppd l=0.5u w=0.5u
X79 VDD VDD VSS rhigh l=4u w=0.5u
X80 VDD a_917_8508# a_1369_6967# VDD sg13_lv_pmos ad=0.68p pd=4.68u as=0.38p ps=2.38u w=2u l=0.13u
X81 a_2804_11753# a_3837_11577# VSS rhigh l=4u w=0.5u
X82 a_3009_6967# a_1267_6967# a_2907_6967# VDD sg13_lv_pmos ad=0.38p pd=2.38u as=0.38p ps=2.38u w=2u l=0.13u
X83 VSS a_4221_4709# a_3883_4709# VSS sg13_lv_nmos ad=0.34p pd=2.68u as=0.34p ps=2.68u w=1u l=0.65u
X84 a_1918_11577# a_885_11577# VSS rhigh l=4u w=0.5u
X85 VSS VSS VSS rppd l=0.5u w=0.5u
X86 a_2805_9195# a_1839_9195# VDD VDD sg13_lv_pmos ad=0.38p pd=2.38u as=0.68p ps=4.68u w=2u l=0.13u
X87 a_1941_8603# a_1839_9195# a_1839_8081# VDD sg13_lv_pmos ad=0.38p pd=2.38u as=0.38p ps=2.38u w=2u l=0.13u
X88 a_1369_5853# a_1267_6967# a_1267_5853# VSS sg13_lv_nmos ad=0.19p pd=1.38u as=0.19p ps=1.38u w=1u l=0.13u
X89 VDD a_917_6931# a_1941_9195# VDD sg13_lv_pmos ad=0.68p pd=4.68u as=0.38p ps=2.38u w=2u l=0.13u
X90 VSS VX a_1369_8081# VSS sg13_lv_nmos ad=0.34p pd=2.68u as=0.19p ps=1.38u w=1u l=0.13u
X91 a_2907_5853# a_1267_5853# a_2805_5853# VSS sg13_lv_nmos ad=0.19p pd=1.38u as=0.19p ps=1.38u w=1u l=0.13u
X92 a_3009_8081# a_2584_8081# a_2907_8081# VSS sg13_lv_nmos ad=0.19p pd=1.38u as=0.19p ps=1.38u w=1u l=0.13u
X93 a_2380_6967# a_1839_6967# VSS VSS sg13_lv_nmos ad=0.34p pd=2.68u as=0.34p ps=2.68u w=1u l=0.13u
X94 VSS VSS VSS rppd l=0.5u w=0.5u
X95 a_3317_10309# a_2907_10309# VDD VDD sg13_lv_pmos ad=0.68p pd=4.68u as=0.68p ps=4.68u w=2u l=0.13u
X96 a_1839_10309# a_1003_4745# VSS VSS sg13_lv_nmos ad=0.19p pd=1.38u as=0.34p ps=2.68u w=1u l=0.13u
X97 VDD VDD VSS rhigh l=0.96u w=0.5u
X98 a_2380_10309# a_1839_10309# VDD VDD sg13_lv_pmos ad=0.68p pd=4.68u as=0.68p ps=4.68u w=2u l=0.13u
X99 VSS VSS VSS rppd l=0.5u w=0.5u
X100 a_3009_10831# a_1267_10309# a_2907_10309# VDD sg13_lv_pmos ad=0.38p pd=2.38u as=0.38p ps=2.38u w=2u l=0.13u
X101 VSS VX a_1369_10309# VSS sg13_lv_nmos ad=0.34p pd=2.68u as=0.19p ps=1.38u w=1u l=0.13u
X102 a_1941_9917# a_1839_10309# a_1839_9195# VSS sg13_lv_nmos ad=0.19p pd=1.38u as=0.19p ps=1.38u w=1u l=0.13u
X103 a_3521_9195# a_3317_9195# VDD VDD sg13_lv_pmos ad=0.38p pd=2.38u as=0.68p ps=4.68u w=2u l=0.13u
X104 VSS VSS VSS rppd l=0.5u w=0.5u
X105 SPIKE a_2130_4709# VDD VDD sg13_lv_pmos ad=0.38p pd=2.38u as=0.38p ps=2.38u w=2u l=0.13u
X106 a_3521_5853# a_3317_5853# VSS VSS sg13_lv_nmos ad=0.34p pd=2.68u as=0.19p ps=1.38u w=1u l=0.13u
X107 a_1369_8603# a_1267_9195# a_1267_8081# VDD sg13_lv_pmos ad=0.38p pd=2.38u as=0.38p ps=2.38u w=2u l=0.13u
X108 VSS VSS VSS rppd l=0.5u w=0.5u
X109 a_3317_5853# a_2907_5853# VSS VSS sg13_lv_nmos ad=0.34p pd=2.68u as=0.34p ps=2.68u w=1u l=0.13u
X110 VDD VDD VSS rhigh l=4u w=0.5u
X111 a_3984_11577# MEM VSS rhigh l=4u w=0.5u
X112 a_2907_8081# a_2584_8081# a_2805_8603# VDD sg13_lv_pmos ad=0.38p pd=2.38u as=0.38p ps=2.38u w=2u l=0.13u
X113 VSS a_1071_4709# a_1003_4745# VSS sg13_lv_nmos ad=0.34p pd=2.68u as=0.19p ps=1.38u w=1u l=0.13u
X114 a_3521_9195# MEM VSS rppd l=0.5u w=0.5u
X115 a_2380_6967# a_1839_6967# VDD VDD sg13_lv_pmos ad=0.68p pd=4.68u as=0.68p ps=4.68u w=2u l=0.13u
X116 VSS VSS VSS rppd l=0.5u w=0.5u
X117 VSS a_3317_10309# a_3521_10309# VSS sg13_lv_nmos ad=0.19p pd=1.38u as=0.19p ps=1.38u w=1u l=0.13u
X118 VSS VSS VSS rppd l=0.5u w=0.5u
X119 a_2805_6375# a_1839_5853# VDD VDD sg13_lv_pmos ad=0.38p pd=2.38u as=0.68p ps=4.68u w=2u l=0.13u
X120 a_2380_8081# a_1839_8081# VSS VSS sg13_lv_nmos ad=0.34p pd=2.68u as=0.34p ps=2.68u w=1u l=0.13u
X121 VSS VSS VSS rppd l=0.5u w=0.5u
X122 VDD a_917_6931# a_1941_6375# VDD sg13_lv_pmos ad=0.68p pd=4.68u as=0.38p ps=2.38u w=2u l=0.13u
X123 VSS VSS VSS rppd l=0.5u w=0.5u
X124 VDD VDD VSS rhigh l=4u w=0.5u
X125 VX a_1771_11577# VSS rhigh l=4u w=0.5u
X126 a_1369_9917# a_1267_10309# a_1267_9195# VSS sg13_lv_nmos ad=0.19p pd=1.38u as=0.19p ps=1.38u w=1u l=0.13u
X127 a_3521_8081# a_3317_8081# VDD VDD sg13_lv_pmos ad=0.68p pd=4.68u as=0.38p ps=2.38u w=2u l=0.13u
X128 VSS a_3207_4709# a_2840_5276# VSS sg13_lv_nmos ad=0.34p pd=2.68u as=0.34p ps=2.68u w=1u l=0.65u
X129 a_2907_9195# a_1267_9195# a_2805_9917# VSS sg13_lv_nmos ad=0.19p pd=1.38u as=0.19p ps=1.38u w=1u l=0.13u
X130 a_3317_8081# a_2907_8081# VDD VDD sg13_lv_pmos ad=0.68p pd=4.68u as=0.68p ps=4.68u w=2u l=0.13u
X131 VSS VSS VSS rppd l=0.5u w=0.5u
X132 VDD a_2769_4709# a_2538_4709# VDD sg13_lv_pmos ad=0.38p pd=2.38u as=0.68p ps=4.68u w=2u l=0.13u
X133 a_2805_7689# a_1839_6967# VSS VSS sg13_lv_nmos ad=0.19p pd=1.38u as=0.34p ps=2.68u w=1u l=0.13u
X134 a_3521_5853# a_3317_5853# VDD VDD sg13_lv_pmos ad=0.38p pd=2.38u as=0.68p ps=4.68u w=2u l=0.13u
X135 a_1941_10831# a_1839_5853# a_1839_10309# VDD sg13_lv_pmos ad=0.38p pd=2.38u as=0.38p ps=2.38u w=2u l=0.13u
X136 a_3317_10309# a_2907_10309# VSS VSS sg13_lv_nmos ad=0.34p pd=2.68u as=0.34p ps=2.68u w=1u l=0.13u
X137 a_1839_9195# VDD VDD VDD sg13_lv_pmos ad=0.38p pd=2.38u as=0.68p ps=4.68u w=2u l=0.13u
X138 VSS VSS VSS rppd l=0.5u w=0.5u
X139 VSS VREF a_1941_7689# VSS sg13_lv_nmos ad=0.34p pd=2.68u as=0.19p ps=1.38u w=1u l=0.13u
X140 VSS VSS VSS rppd l=0.5u w=0.5u
X141 VDD a_3545_4709# a_3207_4709# VDD sg13_lv_pmos ad=0.68p pd=4.68u as=0.68p ps=4.68u w=2u l=0.65u
X142 VDD VDD VSS rhigh l=4u w=0.5u
X143 a_2380_10309# a_1839_10309# VSS VSS sg13_lv_nmos ad=0.34p pd=2.68u as=0.34p ps=2.68u w=1u l=0.13u
X144 a_3521_9195# a_3317_9195# VSS VSS sg13_lv_nmos ad=0.34p pd=2.68u as=0.19p ps=1.38u w=1u l=0.13u
X145 VDD a_1071_4709# a_1003_4745# VDD sg13_lv_pmos ad=0.68p pd=4.68u as=0.38p ps=2.38u w=2u l=0.13u
X146 VSS a_2130_4709# SPIKE VSS sg13_lv_nmos ad=0.34p pd=2.68u as=0.19p ps=1.38u w=1u l=0.13u
X147 a_3009_10309# a_2584_10309# a_2907_10309# VSS sg13_lv_nmos ad=0.19p pd=1.38u as=0.19p ps=1.38u w=1u l=0.13u
X148 a_3317_9195# a_2907_9195# VSS VSS sg13_lv_nmos ad=0.34p pd=2.68u as=0.34p ps=2.68u w=1u l=0.13u
X149 VSS VSS VSS rppd l=0.5u w=0.5u
X150 a_2897_5460# a_2840_5276# VSS VSS sg13_lv_nmos ad=0.19p pd=1.38u as=0.19p ps=1.38u w=1u l=0.13u
X151 VDD VDD VSS rhigh l=0.96u w=0.5u
X152 VSS VSS VSS rppd l=0.5u w=0.5u
X153 a_3521_6967# a_3317_6967# VSS VSS sg13_lv_nmos ad=0.19p pd=1.38u as=0.34p ps=2.68u w=1u l=0.13u
X154 a_2805_6967# a_1839_6967# VDD VDD sg13_lv_pmos ad=0.38p pd=2.38u as=0.68p ps=4.68u w=2u l=0.13u
X155 VSS VSS VSS rppd l=0.5u w=0.5u
X156 a_1267_9195# VDD VDD VDD sg13_lv_pmos ad=0.38p pd=2.38u as=0.68p ps=4.68u w=2u l=0.13u
X157 VDD a_917_6931# a_1941_6967# VDD sg13_lv_pmos ad=0.68p pd=4.68u as=0.38p ps=2.38u w=2u l=0.13u
X158 VSS VX a_1369_5853# VSS sg13_lv_nmos ad=0.34p pd=2.68u as=0.19p ps=1.38u w=1u l=0.13u
X159 VDD a_2380_10309# a_3009_10831# VDD sg13_lv_pmos ad=0.68p pd=4.68u as=0.38p ps=2.38u w=2u l=0.13u
X160 a_3009_5853# a_2584_5853# a_2907_5853# VSS sg13_lv_nmos ad=0.19p pd=1.38u as=0.19p ps=1.38u w=1u l=0.13u
X161 a_3521_10309# a_3317_10309# VDD VDD sg13_lv_pmos ad=0.68p pd=4.68u as=0.38p ps=2.38u w=2u l=0.13u
X162 a_3521_9195# MEM VSS rppd l=0.5u w=0.5u
X163 a_2805_8081# a_1839_8081# VSS VSS sg13_lv_nmos ad=0.19p pd=1.38u as=0.34p ps=2.68u w=1u l=0.13u
X164 VSS VREF a_1941_8081# VSS sg13_lv_nmos ad=0.34p pd=2.68u as=0.19p ps=1.38u w=1u l=0.13u
X165 VSS a_1692_4709# a_1479_4709# VSS sg13_lv_nmos ad=0.19p pd=1.38u as=0.34p ps=2.68u w=1u l=0.13u
X166 a_1839_5853# VDD VDD VDD sg13_lv_pmos ad=0.38p pd=2.38u as=0.68p ps=4.68u w=2u l=0.13u
X167 a_1267_10309# VDD VDD VDD sg13_lv_pmos ad=0.38p pd=2.38u as=0.68p ps=4.68u w=2u l=0.13u
X168 a_3521_5853# MEM VSS rppd l=0.5u w=0.5u
X169 VSS VSS VSS rppd l=0.5u w=0.5u
X170 a_3521_6967# a_3317_6967# VDD VDD sg13_lv_pmos ad=0.38p pd=2.38u as=0.68p ps=4.68u w=2u l=0.13u
X171 VDD a_3317_9195# a_3521_9195# VDD sg13_lv_pmos ad=0.38p pd=2.38u as=0.38p ps=2.38u w=2u l=0.13u
X172 VDD a_2130_4709# SPIKE VDD sg13_lv_pmos ad=0.68p pd=4.68u as=0.38p ps=2.38u w=2u l=0.13u
X173 VSS a_3883_4709# a_3545_4709# VSS sg13_lv_nmos ad=0.34p pd=2.68u as=0.34p ps=2.68u w=1u l=0.65u
X174 VDD a_917_8508# a_1369_8603# VDD sg13_lv_pmos ad=0.68p pd=4.68u as=0.38p ps=2.38u w=2u l=0.13u
X175 VSS VSS VSS rppd l=0.5u w=0.5u
X176 VSS COMP a_4221_4709# VSS sg13_lv_nmos ad=0.34p pd=2.68u as=0.34p ps=2.68u w=1u l=0.65u
X177 VSS VSS VSS rppd l=0.5u w=0.5u
X178 a_3009_8603# a_1267_8081# a_2907_8081# VDD sg13_lv_pmos ad=0.38p pd=2.38u as=0.38p ps=2.38u w=2u l=0.13u
X179 a_3521_8081# a_3317_8081# VSS VSS sg13_lv_nmos ad=0.19p pd=1.38u as=0.34p ps=2.68u w=1u l=0.13u
X180 a_1941_10309# a_1839_5853# a_1839_10309# VSS sg13_lv_nmos ad=0.19p pd=1.38u as=0.19p ps=1.38u w=1u l=0.13u
X181 VDD a_2380_9195# a_3009_9195# VDD sg13_lv_pmos ad=0.68p pd=4.68u as=0.38p ps=2.38u w=2u l=0.13u
X182 a_2584_9195# a_1267_9195# VDD VDD sg13_lv_pmos ad=0.68p pd=4.68u as=0.68p ps=4.68u w=2u l=0.13u
X183 a_1839_6967# VSS VSS VSS sg13_lv_nmos ad=0.19p pd=1.38u as=0.34p ps=2.68u w=1u l=0.13u
X184 COMP a_4828_5366# VDD VDD sg13_lv_pmos ad=0.38p pd=2.38u as=0.68p ps=4.68u w=2u l=0.13u
X185 a_2951_11577# a_3837_11577# VSS rhigh l=4u w=0.5u
X186 a_2380_5853# a_1839_5853# VSS VSS sg13_lv_nmos ad=0.34p pd=2.68u as=0.34p ps=2.68u w=1u l=0.13u
X187 VSS VSS VSS rppd l=0.5u w=0.5u
X188 a_1267_5853# VDD VDD VDD sg13_lv_pmos ad=0.38p pd=2.38u as=0.68p ps=4.68u w=2u l=0.13u
X189 VSS VSS VSS rppd l=0.5u w=0.5u
X190 VSS VSS VSS rppd l=0.5u w=0.5u
X191 VDD VDD VSS rhigh l=0.96u w=0.5u
X192 VDD VDD VSS rhigh l=0.96u w=0.5u
X193 VSS VSS VSS rppd l=0.5u w=0.5u
X194 VDD a_917_6931# a_1941_10831# VDD sg13_lv_pmos ad=0.68p pd=4.68u as=0.38p ps=2.38u w=2u l=0.13u
X195 VSS VX a_1369_9917# VSS sg13_lv_nmos ad=0.34p pd=2.68u as=0.19p ps=1.38u w=1u l=0.13u
X196 a_3009_9917# a_2584_9195# a_2907_9195# VSS sg13_lv_nmos ad=0.19p pd=1.38u as=0.19p ps=1.38u w=1u l=0.13u
X197 VDD a_1692_4709# a_1479_4709# VDD sg13_lv_pmos ad=0.38p pd=2.38u as=0.68p ps=4.68u w=2u l=0.13u
X198 VSS VSS VSS rppd l=0.5u w=0.5u
X199 VSS a_2380_10309# a_3009_10309# VSS sg13_lv_nmos ad=0.34p pd=2.68u as=0.19p ps=1.38u w=1u l=0.13u
X200 VSS VSS VSS rppd l=0.5u w=0.5u
X201 VDD a_3317_5853# a_3521_5853# VDD sg13_lv_pmos ad=0.38p pd=2.38u as=0.38p ps=2.38u w=2u l=0.13u
X202 a_3521_10309# a_3317_10309# VSS VSS sg13_lv_nmos ad=0.34p pd=2.68u as=0.19p ps=1.38u w=1u l=0.13u
X203 a_1267_6967# VSS VSS VSS sg13_lv_nmos ad=0.19p pd=1.38u as=0.34p ps=2.68u w=1u l=0.13u
X204 VSS VSS VSS rppd l=0.5u w=0.5u
X205 a_1839_6967# VDD VDD VDD sg13_lv_pmos ad=0.38p pd=2.38u as=0.68p ps=4.68u w=2u l=0.13u
X206 a_1941_9195# a_1839_10309# a_1839_9195# VDD sg13_lv_pmos ad=0.38p pd=2.38u as=0.38p ps=2.38u w=2u l=0.13u
X207 a_2380_8081# a_1839_8081# VDD VDD sg13_lv_pmos ad=0.68p pd=4.68u as=0.68p ps=4.68u w=2u l=0.13u
X208 a_4828_5366# MEM VDD VDD sg13_lv_pmos ad=0.38p pd=2.38u as=0.38p ps=2.38u w=2u l=0.13u
X209 VSS VSS VSS rppd l=0.5u w=0.5u
X210 a_1267_10309# a_1003_4745# VSS VSS sg13_lv_nmos ad=0.19p pd=1.38u as=0.34p ps=2.68u w=1u l=0.13u
X211 VDD a_4221_4709# a_3883_4709# VDD sg13_lv_pmos ad=0.68p pd=4.68u as=0.68p ps=4.68u w=2u l=0.65u
X212 VDD a_2380_5853# a_3009_6375# VDD sg13_lv_pmos ad=0.68p pd=4.68u as=0.38p ps=2.38u w=2u l=0.13u
X213 a_1839_8081# a_1003_4745# VSS VSS sg13_lv_nmos ad=0.19p pd=1.38u as=0.34p ps=2.68u w=1u l=0.13u
X214 a_2584_5853# a_1267_5853# VDD VDD sg13_lv_pmos ad=0.68p pd=4.68u as=0.68p ps=4.68u w=2u l=0.13u
X215 a_3984_11577# a_2951_11577# VSS rhigh l=4u w=0.5u
X216 VSS VSS VSS rppd l=0.5u w=0.5u
X217 a_2769_4709# COMP a_2897_5460# VSS sg13_lv_nmos ad=0.34p pd=2.68u as=0.19p ps=1.38u w=1u l=0.13u
X218 VSS a_3317_6967# a_3521_6967# VSS sg13_lv_nmos ad=0.19p pd=1.38u as=0.19p ps=1.38u w=1u l=0.13u
X219 VSS VSS VSS rppd l=0.5u w=0.5u
X220 a_2380_9195# a_1839_9195# VSS VSS sg13_lv_nmos ad=0.34p pd=2.68u as=0.34p ps=2.68u w=1u l=0.13u
X221 a_1267_6967# VDD VDD VDD sg13_lv_pmos ad=0.38p pd=2.38u as=0.68p ps=4.68u w=2u l=0.13u
X222 a_885_11577# a_1771_11577# VSS rhigh l=4u w=0.5u
X223 a_1369_9195# a_1267_10309# a_1267_9195# VDD sg13_lv_pmos ad=0.38p pd=2.38u as=0.38p ps=2.38u w=2u l=0.13u
X224 VSS a_2380_6967# a_3009_7689# VSS sg13_lv_nmos ad=0.34p pd=2.68u as=0.19p ps=1.38u w=1u l=0.13u
X225 a_2907_9195# a_2584_9195# a_2805_9195# VDD sg13_lv_pmos ad=0.38p pd=2.38u as=0.38p ps=2.38u w=2u l=0.13u
X226 VSS VSS VSS rppd l=0.5u w=0.5u
X227 a_2584_6967# a_1267_6967# VSS VSS sg13_lv_nmos ad=0.34p pd=2.68u as=0.34p ps=2.68u w=1u l=0.13u
X228 a_2805_5853# a_1839_5853# VSS VSS sg13_lv_nmos ad=0.19p pd=1.38u as=0.34p ps=2.68u w=1u l=0.13u
X229 VSS VSS VSS rppd l=0.5u w=0.5u
X230 a_1267_8081# a_1003_4745# VSS VSS sg13_lv_nmos ad=0.19p pd=1.38u as=0.34p ps=2.68u w=1u l=0.13u
X231 VSS VREF a_1941_5853# VSS sg13_lv_nmos ad=0.34p pd=2.68u as=0.19p ps=1.38u w=1u l=0.13u
X232 a_3521_5853# MEM VSS rppd l=0.5u w=0.5u
X233 a_1692_4709# COMP VSS VSS sg13_lv_nmos ad=0.19p pd=1.38u as=0.19p ps=1.38u w=1u l=0.13u
X234 VSS VREF a_1941_10309# VSS sg13_lv_nmos ad=0.34p pd=2.68u as=0.19p ps=1.38u w=1u l=0.13u
X235 a_1941_6375# a_1839_6967# a_1839_5853# VDD sg13_lv_pmos ad=0.38p pd=2.38u as=0.38p ps=2.38u w=2u l=0.13u
X236 VDD VDD VSS rhigh l=4u w=0.5u
X237 VSS VSS VSS rppd l=0.5u w=0.5u
X238 a_917_6931# VREF VSS VSS sg13_lv_nmos ad=0.34p pd=2.68u as=0.34p ps=2.68u w=1u l=0.13u
X239 COMP a_4828_5366# VSS VSS sg13_lv_nmos ad=0.19p pd=1.38u as=0.34p ps=2.68u w=1u l=0.13u
X240 VDD a_3317_6967# a_3521_6967# VDD sg13_lv_pmos ad=0.38p pd=2.38u as=0.38p ps=2.38u w=2u l=0.13u
X241 a_3521_6967# MEM VSS rppd l=0.5u w=0.5u
X242 a_3521_9195# a_3317_9195# VDD VDD sg13_lv_pmos ad=0.68p pd=4.68u as=0.38p ps=2.38u w=2u l=0.13u
X243 VSS VSS VSS rppd l=0.5u w=0.5u
X244 a_3521_10309# MEM VSS rppd l=0.5u w=0.5u
X245 VSS VSS VSS rppd l=0.5u w=0.5u
X246 VSS a_1479_4709# a_1071_4709# VSS sg13_lv_nmos ad=0.34p pd=2.68u as=0.34p ps=2.68u w=1u l=0.13u
X247 a_3521_5853# a_3317_5853# VSS VSS sg13_lv_nmos ad=0.19p pd=1.38u as=0.34p ps=2.68u w=1u l=0.13u
X248 a_3317_9195# a_2907_9195# VDD VDD sg13_lv_pmos ad=0.68p pd=4.68u as=0.68p ps=4.68u w=2u l=0.13u
X249 a_2805_8603# a_1839_8081# VDD VDD sg13_lv_pmos ad=0.38p pd=2.38u as=0.68p ps=4.68u w=2u l=0.13u
X250 VSS a_3317_8081# a_3521_8081# VSS sg13_lv_nmos ad=0.19p pd=1.38u as=0.19p ps=1.38u w=1u l=0.13u
X251 a_2584_6967# a_1267_6967# VDD VDD sg13_lv_pmos ad=0.68p pd=4.68u as=0.68p ps=4.68u w=2u l=0.13u
X252 VDD a_2380_6967# a_3009_6967# VDD sg13_lv_pmos ad=0.68p pd=4.68u as=0.38p ps=2.38u w=2u l=0.13u
X253 VDD a_917_6931# a_1941_8603# VDD sg13_lv_pmos ad=0.68p pd=4.68u as=0.38p ps=2.38u w=2u l=0.13u
X254 VDD a_4828_5366# COMP VDD sg13_lv_pmos ad=0.38p pd=2.38u as=0.38p ps=2.38u w=2u l=0.13u
X255 a_1369_10831# a_1267_5853# a_1267_10309# VDD sg13_lv_pmos ad=0.38p pd=2.38u as=0.38p ps=2.38u w=2u l=0.13u
X256 a_1941_7689# a_1839_8081# a_1839_6967# VSS sg13_lv_nmos ad=0.19p pd=1.38u as=0.19p ps=1.38u w=1u l=0.13u
X257 VDD a_3207_4709# a_2840_5276# VDD sg13_lv_pmos ad=0.68p pd=4.68u as=0.68p ps=4.68u w=2u l=0.65u
X258 VSS a_1071_4709# a_1003_4745# VSS sg13_lv_nmos ad=0.19p pd=1.38u as=0.34p ps=2.68u w=1u l=0.13u
X259 VSS VSS VSS rppd l=0.5u w=0.5u
X260 VSS a_2380_8081# a_3009_8081# VSS sg13_lv_nmos ad=0.34p pd=2.68u as=0.19p ps=1.38u w=1u l=0.13u
X261 a_1369_6375# a_1267_6967# a_1267_5853# VDD sg13_lv_pmos ad=0.38p pd=2.38u as=0.38p ps=2.38u w=2u l=0.13u
X262 a_2584_8081# a_1267_8081# VSS VSS sg13_lv_nmos ad=0.34p pd=2.68u as=0.34p ps=2.68u w=1u l=0.13u
X263 a_917_6931# a_917_6931# VDD VDD sg13_lv_pmos ad=0.68p pd=4.68u as=0.68p ps=4.68u w=2u l=0.13u
X264 a_2907_5853# a_2584_5853# a_2805_6375# VDD sg13_lv_pmos ad=0.38p pd=2.38u as=0.38p ps=2.38u w=2u l=0.13u
X265 a_3521_6967# MEM VSS rppd l=0.5u w=0.5u
X266 VDD VDD VSS rhigh l=4u w=0.5u
X267 a_3521_10309# MEM VSS rppd l=0.5u w=0.5u
X268 a_917_8508# VX VSS VSS sg13_lv_nmos ad=0.34p pd=2.68u as=0.34p ps=2.68u w=1u l=0.13u
X269 a_1820_4745# COMP VDD VDD sg13_lv_pmos ad=0.38p pd=2.38u as=0.38p ps=2.38u w=2u l=0.13u
X270 a_4828_5366# MEM VSS VSS sg13_lv_nmos ad=0.19p pd=1.38u as=0.19p ps=1.38u w=1u l=0.13u
X271 a_1918_11577# a_2804_11753# VSS rhigh l=4u w=0.5u
X272 VDD VDD VSS rhigh l=4u w=0.5u
X273 a_2805_9917# a_1839_9195# VSS VSS sg13_lv_nmos ad=0.19p pd=1.38u as=0.34p ps=2.68u w=1u l=0.13u
X274 a_3521_8081# a_3317_8081# VDD VDD sg13_lv_pmos ad=0.38p pd=2.38u as=0.68p ps=4.68u w=2u l=0.13u
X275 a_3521_10309# a_3317_10309# VDD VDD sg13_lv_pmos ad=0.38p pd=2.38u as=0.68p ps=4.68u w=2u l=0.13u
X276 VSS VREF a_1941_9917# VSS sg13_lv_nmos ad=0.34p pd=2.68u as=0.19p ps=1.38u w=1u l=0.13u
X277 VSS VSS VSS rppd l=0.5u w=0.5u
X278 VSS VSS VSS rppd l=0.5u w=0.5u
X279 a_2584_10309# a_1267_10309# VDD VDD sg13_lv_pmos ad=0.68p pd=4.68u as=0.68p ps=4.68u w=2u l=0.13u
X280 a_3521_5853# a_3317_5853# VDD VDD sg13_lv_pmos ad=0.68p pd=4.68u as=0.38p ps=2.38u w=2u l=0.13u
X281 a_1369_7689# a_1267_8081# a_1267_6967# VSS sg13_lv_nmos ad=0.19p pd=1.38u as=0.19p ps=1.38u w=1u l=0.13u
X282 a_1941_6967# a_1839_8081# a_1839_6967# VDD sg13_lv_pmos ad=0.38p pd=2.38u as=0.38p ps=2.38u w=2u l=0.13u
X283 a_2769_4709# a_2840_5276# VDD VDD sg13_lv_pmos ad=0.38p pd=2.38u as=0.38p ps=2.38u w=2u l=0.13u
X284 VDD VDD VSS rhigh l=0.96u w=0.5u
X285 VDD VDD VSS rhigh l=0.96u w=0.5u
X286 a_2907_6967# a_1267_6967# a_2805_7689# VSS sg13_lv_nmos ad=0.19p pd=1.38u as=0.19p ps=1.38u w=1u l=0.13u
X287 VDD MEM a_4828_5366# VDD sg13_lv_pmos ad=0.68p pd=4.68u as=0.38p ps=2.38u w=2u l=0.13u
X288 VDD a_1479_4709# a_1071_4709# VDD sg13_lv_pmos ad=0.68p pd=4.68u as=0.68p ps=4.68u w=2u l=0.13u
X289 a_3317_5853# a_2907_5853# VDD VDD sg13_lv_pmos ad=0.68p pd=4.68u as=0.68p ps=4.68u w=2u l=0.13u
X290 VDD VDD VSS rhigh l=4u w=0.5u
X291 a_2805_10831# a_1839_10309# VDD VDD sg13_lv_pmos ad=0.38p pd=2.38u as=0.68p ps=4.68u w=2u l=0.13u
X292 a_1941_8081# a_1839_9195# a_1839_8081# VSS sg13_lv_nmos ad=0.19p pd=1.38u as=0.19p ps=1.38u w=1u l=0.13u
X293 a_1839_5853# a_1003_4745# VSS VSS sg13_lv_nmos ad=0.19p pd=1.38u as=0.34p ps=2.68u w=1u l=0.13u
C0 a_2004_11577# a_885_11577# 0.05294f
C1 COMP a_3317_5853# 0.02406f
C2 COMP a_2538_4709# 0.04697f
C3 a_4351_11043# a_4735_11043# 0.01085f
C4 a_3317_10309# VDD 0.74568f
C5 a_1820_4745# RST 0.05784f
C6 VDD a_4351_7055# 0.02919f
C7 a_3317_8081# a_3317_9195# 0.01806f
C8 VDD a_1267_6967# 0.83508f
C9 a_1003_4745# SPIKE 0.21681f
C10 VDD a_1941_6375# 0.23537f
C11 a_4351_8815# a_4735_8815# 0.01085f
C12 a_4351_10831# MEM 0.02682f
C13 VDD VREF 0.22781f
C14 a_1369_8081# a_1267_9195# 0.01603f
C15 a_2805_9917# a_2584_9195# 0.01463f
C16 a_1267_8081# a_917_8508# 0.52305f
C17 a_4735_10616# a_4735_10831# 0.02872f
C18 a_2584_6967# a_2380_6967# 0.83154f
C19 a_3317_10309# a_3317_9195# 0.03047f
C20 VX a_1267_8081# 0.19947f
C21 a_2004_11753# a_1918_11577# 0.01534f
C22 VDD a_1692_4709# 0.14948f
C23 a_1839_5853# SPIKE 0.01495f
C24 a_3967_10616# a_3967_10831# 0.02872f
C25 VDD a_1839_10309# 0.74384f
C26 a_1267_8081# a_1267_9195# 0.47286f
C27 a_2907_9195# a_2380_9195# 0.20077f
C28 VDD a_2907_5853# 0.18898f
C29 a_1839_9195# a_1267_8081# 0.03204f
C30 a_2004_11441# a_2004_11577# 0.29305f
C31 a_4351_7482# a_4735_7482# 0.01085f
C32 a_3967_7267# a_3967_7482# 0.02872f
C33 a_2907_8081# a_3009_8081# 0.09917f
C34 a_2805_9917# a_1267_9195# 0.01675f
C35 a_3207_4709# RST 0.10055f
C36 a_1369_9195# a_917_8508# 0.01353f
C37 a_3207_4709# a_2840_5276# 0.12877f
C38 a_2584_6967# a_2805_6967# 0.04511f
C39 a_3037_11577# a_3837_11577# 0.01566f
C40 a_5078_11441# a_5078_11577# 0.07033f
C41 a_917_6931# a_1267_6967# 0.14548f
C42 VDD a_3883_4709# 0.54915f
C43 a_917_6931# a_1941_6375# 0.01325f
C44 VDD a_538_11577# 0.03563f
C45 VREF a_917_6931# 5.11101f
C46 a_1369_9195# a_1267_9195# 0.22323f
C47 a_2907_5853# a_2380_5853# 0.19738f
C48 VDD a_3967_10831# 0.011f
C49 a_4351_7267# MEM 0.02666f
C50 a_4070_11577# a_2951_11577# 0.05255f
C51 a_4351_6375# a_4735_6375# 0.01085f
C52 a_1003_4745# RST 0.56156f
C53 a_1839_8081# VREF 0.21432f
C54 a_4735_6375# a_4735_6587# 0.02952f
C55 VDD a_5078_11753# 0.03302f
C56 a_2907_9195# a_3009_9195# 0.21534f
C57 a_2380_8081# a_2380_6967# 0.03435f
C58 a_917_6931# a_1839_10309# 0.50569f
C59 a_3967_7482# a_4351_7482# 0.01085f
C60 a_1003_4745# a_1267_8081# 0.14084f
C61 a_1369_9195# a_1267_10309# 0.01956f
C62 a_4351_7482# MEM 0.02653f
C63 a_4351_8603# a_3967_8603# 0.01085f
C64 a_2805_8081# a_2907_8081# 0.09917f
C65 a_4828_5366# MEM 0.49351f
C66 a_3009_9917# a_2584_9195# 0.04702f
C67 a_3967_9710# a_3967_9922# 0.02952f
C68 VDD a_2380_5853# 0.53846f
C69 a_1839_6967# a_1267_6967# 0.86515f
C70 VDD a_3317_9195# 0.72635f
C71 a_1839_6967# a_1941_6375# 0.02756f
C72 a_1839_6967# VREF 0.20506f
C73 a_4351_6160# a_4735_6160# 0.01085f
C74 a_1839_5853# a_1267_8081# 0.25436f
C75 VDD a_3967_6587# 0.03605f
C76 a_1369_6967# a_917_8508# 0.01344f
C77 VDD a_4070_11441# 0.33809f
C78 a_4735_8603# MEM 0.01018f
C79 VDD a_917_6931# 1.27003f
C80 a_2004_11753# a_885_11577# 0.02034f
C81 a_1267_8081# a_2907_8081# 0.37587f
C82 COMP a_1692_4709# 0.44996f
C83 VDD a_1839_8081# 0.73208f
C84 a_971_11577# a_885_11577# 0.05224f
C85 a_3521_9195# a_4351_9495# 0.024f
C86 a_971_11753# a_971_11577# 0.13024f
C87 a_2380_6967# a_3317_6967# 0.0172f
C88 COMP a_2907_5853# 0.01039f
C89 a_1839_5853# a_2584_5853# 0.20652f
C90 a_2380_10309# a_2380_9195# 0.03435f
C91 a_1267_9195# a_1941_9195# 0.01706f
C92 VDD a_1071_4709# 0.71341f
C93 a_1839_9195# a_1941_9195# 0.21287f
C94 a_4735_10616# a_4351_10616# 0.01085f
C95 VDD a_1839_6967# 0.73528f
C96 COMP a_3883_4709# 0.20413f
C97 a_2584_9195# a_1267_9195# 0.70219f
C98 a_1369_10309# a_1267_5853# 0.01315f
C99 a_4221_4709# a_3883_4709# 0.15167f
C100 a_1839_9195# a_2584_9195# 0.20139f
C101 a_4351_9922# a_3967_9922# 0.01085f
C102 VDD COMP 0.98967f
C103 a_4735_8388# a_4351_8388# 0.01085f
C104 VDD a_1771_11577# 0.13616f
C105 VX a_917_8508# 4.07577f
C106 a_4735_9710# a_4735_9495# 0.02872f
C107 a_2951_11577# a_3037_11753# 0.02034f
C108 a_3967_8176# a_3967_8388# 0.02952f
C109 a_4221_4709# VDD 0.55327f
C110 a_2805_5853# a_2584_5853# 0.01463f
C111 a_1839_8081# a_917_6931# 0.46393f
C112 a_2380_6967# a_1267_6967# 0.624f
C113 a_2004_11753# a_2004_11933# 0.12339f
C114 a_917_8508# a_1267_9195# 0.62303f
C115 a_3967_8815# a_4351_8815# 0.01085f
C116 a_1941_10831# a_1839_10309# 0.20989f
C117 VX a_1267_9195# 0.19267f
C118 VDD a_4735_8815# 0.02946f
C119 a_4735_9710# a_4351_9710# 0.01085f
C120 a_3317_10309# a_3521_10309# 0.40835f
C121 VDD a_3037_11441# 0.37462f
C122 COMP a_2380_5853# 0.02344f
C123 a_1839_5853# a_2584_8081# 0.01989f
C124 a_3521_8081# a_3521_9195# 0.03716f
C125 a_1267_10309# a_2907_10309# 0.37961f
C126 a_3009_8603# a_2907_8081# 0.21534f
C127 VDD a_2805_8603# 0.23422f
C128 a_1839_9195# a_1267_9195# 0.57006f
C129 a_1267_10309# a_917_8508# 0.39966f
C130 a_4351_10831# a_4351_11043# 0.02952f
C131 a_3984_11577# a_4070_11753# 0.01578f
C132 a_4351_6375# MEM 0.02596f
C133 a_2584_8081# a_2907_8081# 0.34325f
C134 a_1839_6967# a_917_6931# 0.68693f
C135 VX a_1267_10309# 0.21105f
C136 a_1267_10309# a_1267_9195# 0.16814f
C137 a_1839_8081# a_1839_6967# 0.24755f
C138 a_4351_5948# a_4351_6160# 0.02952f
C139 VDD a_1941_10831# 0.23921f
C140 a_3521_5853# MEM 0.1089f
C141 a_4351_6375# a_4351_6160# 0.02872f
C142 a_1839_9195# a_1267_10309# 0.01073f
C143 a_4351_8176# a_4351_8388# 0.02952f
C144 a_538_11441# a_538_11577# 0.07033f
C145 a_1003_4745# a_917_8508# 0.15027f
C146 a_1267_6967# a_1941_6967# 0.01432f
C147 a_1839_5853# a_2584_9195# 0.02017f
C148 a_1839_8081# a_1941_8081# 0.10389f
C149 a_3521_5853# a_4351_6160# 0.02437f
C150 VDD a_538_11441# 0.06326f
C151 VX a_1003_4745# 6.16406f
C152 VDD a_2380_6967# 0.53678f
C153 VDD a_2907_9195# 0.18959f
C154 a_1369_7689# a_1267_6967# 0.09918f
C155 a_4351_9495# MEM 0.02673f
C156 a_1003_4745# a_1267_9195# 0.05712f
C157 a_3967_6160# a_4351_6160# 0.01085f
C158 a_1839_6967# a_1941_5853# 0.01612f
C159 VDD a_2805_9195# 0.23422f
C160 a_1003_4745# a_1839_9195# 1.10729f
C161 a_3037_11933# a_3037_11753# 0.12339f
C162 a_2805_10831# a_2584_10309# 0.04511f
C163 VDD a_3521_10309# 0.79931f
C164 a_1003_4745# a_1267_10309# 0.11201f
C165 VDD a_971_11933# 0.11812f
C166 a_1839_5853# a_1267_9195# 0.39656f
C167 a_2951_11577# a_3837_11577# 0.02617f
C168 VDD a_2805_6967# 0.23422f
C169 a_2804_11753# a_885_11577# 0.0384f
C170 a_4221_4709# COMP 0.35342f
C171 a_3317_10309# a_2380_10309# 0.0172f
C172 VDD a_1918_11577# 0.13874f
C173 a_3317_9195# a_2907_9195# 0.14521f
C174 a_1839_5853# a_1839_9195# 0.03485f
C175 a_2380_8081# a_3009_8081# 0.01182f
C176 a_3967_10616# a_4351_10616# 0.01085f
C177 a_1369_6375# a_1267_5853# 0.21646f
C178 a_2538_4709# a_2769_4709# 0.13146f
C179 a_3967_9710# a_3967_9495# 0.02872f
C180 a_2907_5853# a_2805_6375# 0.20304f
C181 a_1839_5853# a_1267_10309# 0.09012f
C182 a_4735_5948# a_4735_6160# 0.02952f
C183 VDD a_1941_6967# 0.2355f
C184 a_1839_5853# a_1941_10309# 0.01457f
C185 a_3521_8081# MEM 0.10908f
C186 a_3967_7267# a_3967_7055# 0.02952f
C187 a_2380_10309# a_1839_10309# 0.20354f
C188 a_2538_4709# RST 0.024f
C189 a_2840_5276# a_2538_4709# 0.02801f
C190 VDD a_2805_6375# 0.23422f
C191 a_1839_5853# a_1003_4745# 0.24582f
C192 a_1839_6967# a_2380_6967# 0.19576f
C193 a_3967_7694# a_3967_7482# 0.02952f
C194 a_3967_5948# a_4351_5948# 0.01085f
C195 a_4735_7267# a_4735_7482# 0.02872f
C196 a_1267_8081# a_1267_5853# 0.16116f
C197 a_3967_7267# a_4351_7267# 0.01085f
C198 a_3009_6967# a_2907_6967# 0.21534f
C199 a_1941_9917# a_1839_9195# 0.09921f
C200 MEM a_3521_6967# 0.10906f
C201 a_1839_10309# a_2584_10309# 0.20228f
C202 a_4735_8388# a_4735_8176# 0.02952f
C203 a_917_6931# a_1941_6967# 0.0153f
C204 VDD a_2380_10309# 0.54104f
C205 a_2380_8081# a_1267_8081# 0.59629f
C206 a_1839_8081# a_1941_6967# 0.01698f
C207 VDD a_3521_9195# 0.73911f
C208 a_3967_5948# a_3967_6160# 0.02952f
C209 VDD a_885_11577# 1.48831f
C210 VDD a_1941_8603# 0.23535f
C211 a_1267_5853# a_2584_5853# 0.73923f
C212 a_1839_8081# a_1941_7689# 0.02364f
C213 a_971_11753# VDD 0.08589f
C214 VDD a_3967_8815# 0.03605f
C215 VDD a_1369_8603# 0.23575f
C216 a_4351_7267# a_4351_7482# 0.02872f
C217 VDD a_2584_10309# 0.49243f
C218 a_4735_7267# MEM 0.01009f
C219 VREF SPIKE 0.02311f
C220 a_2584_8081# a_2584_6967# 0.07395f
C221 a_1771_11577# a_1918_11577# 0.17736f
C222 a_4351_8388# MEM 0.02645f
C223 VDD a_3009_10831# 0.23846f
C224 a_4735_9922# a_4351_9922# 0.01085f
C225 a_1839_6967# a_1941_6967# 0.20989f
C226 VDD a_3037_11577# 0.09042f
C227 VDD a_4070_11753# 0.08633f
C228 a_2805_7689# a_2907_6967# 0.09917f
C229 a_4735_10404# a_4351_10404# 0.01085f
C230 a_3521_9195# a_3317_9195# 0.40835f
C231 a_3037_11753# a_3837_11577# 0.01566f
C232 VDD a_4070_11933# 0.11846f
C233 a_1692_4709# SPIKE 0.24601f
C234 a_1839_6967# a_1941_7689# 0.09918f
C235 a_3545_4709# a_3883_4709# 0.15149f
C236 a_3009_9917# a_2380_9195# 0.01182f
C237 a_4735_8176# a_4351_8176# 0.01085f
C238 a_1267_6967# a_1369_6375# 0.03293f
C239 a_3545_4709# VDD 0.54685f
C240 a_4351_5948# a_4735_5948# 0.01085f
C241 a_3317_8081# a_1267_8081# 0.01086f
C242 a_917_6931# a_1941_8603# 0.01258f
C243 a_2951_11577# a_3984_11577# 0.02622f
C244 VDD a_2004_11441# 0.37606f
C245 a_4351_8603# MEM 0.02673f
C246 a_2907_9195# a_2805_9195# 0.20304f
C247 a_1839_8081# a_1941_8603# 0.21415f
C248 VDD a_2004_11933# 0.11603f
C249 a_3967_10616# a_3967_10404# 0.02952f
C250 a_2130_4709# a_2538_4709# 0.13318f
C251 a_2584_9195# a_2380_9195# 0.79681f
C252 VDD SPIKE 0.71716f
C253 VDD a_3967_11043# 0.04384f
C254 a_3967_10831# a_3967_11043# 0.02952f
C255 a_3967_8815# a_3967_8603# 0.02952f
C256 a_4070_11577# a_3984_11577# 0.01578f
C257 a_2584_8081# a_2380_8081# 0.83154f
C258 a_1267_10309# a_1369_10831# 0.21767f
C259 a_2907_8081# a_2907_6967# 0.01112f
C260 a_1267_8081# a_1267_6967# 0.22895f
C261 VREF a_1267_8081# 0.05525f
C262 a_3521_9195# a_4351_9710# 0.02437f
C263 a_1692_4709# RST 0.27747f
C264 VDD a_1369_6375# 0.23577f
C265 a_2380_9195# a_1267_9195# 0.63385f
C266 COMP a_2897_5460# 0.04778f
C267 VDD a_2769_4709# 0.60809f
C268 VDD MEM 3.06374f
C269 a_1771_11577# a_885_11577# 0.02649f
C270 a_1692_4709# a_1479_4709# 0.13829f
C271 a_1839_9195# a_2380_9195# 0.19537f
C272 a_971_11753# a_1771_11577# 0.01602f
C273 VDD a_538_11933# 0.03079f
C274 a_2584_6967# a_2805_7689# 0.01463f
C275 a_4735_9283# a_4351_9283# 0.01085f
C276 a_1267_5853# a_917_8508# 0.17251f
C277 a_4351_7694# a_4735_7694# 0.01085f
C278 VDD a_4735_11043# 0.03776f
C279 VX a_1267_5853# 0.15826f
C280 a_3883_4709# RST 0.10008f
C281 a_1267_5853# a_1267_9195# 0.76752f
C282 a_4351_8388# a_3967_8388# 0.01085f
C283 VDD RST 0.50078f
C284 VDD a_2840_5276# 0.32993f
C285 a_2907_6967# a_3009_7689# 0.09917f
C286 a_3009_9195# a_1267_9195# 0.01987f
C287 a_3545_4709# COMP 0.2067f
C288 VDD a_1267_8081# 0.79904f
C289 a_2804_11753# a_2951_11577# 0.03813f
C290 VDD a_1479_4709# 0.5212f
C291 a_2907_5853# a_2584_5853# 0.3427f
C292 a_3521_10309# a_4351_10616# 0.02437f
C293 a_3037_11577# a_3037_11441# 0.29305f
C294 a_1267_10309# a_1267_5853# 0.33245f
C295 a_1071_4709# SPIKE 0.12757f
C296 a_1003_4745# a_1369_5853# 0.0153f
C297 a_2004_11753# a_2004_11577# 0.13024f
C298 a_1839_5853# a_2584_6967# 0.02221f
C299 a_2907_5853# a_3009_5853# 0.09917f
C300 COMP SPIKE 0.51954f
C301 a_1369_9917# a_1267_9195# 0.09919f
C302 a_3521_9195# a_2907_9195# 0.01239f
C303 a_2805_10831# a_2907_10309# 0.20304f
C304 a_1267_6967# a_1369_6967# 0.22361f
C305 VDD a_2584_5853# 0.48192f
C306 VDD a_1369_9195# 0.23614f
C307 a_1839_5853# a_2380_9195# 0.02077f
C308 a_1003_4745# a_1267_5853# 4.37305f
C309 a_4735_9495# MEM 0.01018f
C310 a_2805_10309# a_2584_10309# 0.01463f
C311 a_4351_6375# a_3967_6375# 0.01085f
C312 a_3521_9195# a_3521_10309# 0.02864f
C313 a_1369_9917# a_1267_10309# 0.02342f
C314 a_917_6931# a_1267_8081# 0.02941f
C315 a_1692_4709# a_2130_4709# 0.0123f
C316 VDD a_5078_11441# 0.07054f
C317 COMP a_2769_4709# 0.14498f
C318 a_2584_5853# a_2380_5853# 0.83117f
C319 MEM a_4351_9710# 0.02645f
C320 COMP MEM 0.14129f
C321 a_3967_9710# a_4351_9710# 0.01085f
C322 a_971_11753# a_971_11933# 0.12339f
C323 a_1839_5853# a_1267_5853# 0.96879f
C324 a_1839_8081# a_1267_8081# 0.8335f
C325 a_885_11577# a_1918_11577# 0.02597f
C326 a_3967_9283# a_4351_9283# 0.01085f
C327 a_4735_7267# a_4735_7055# 0.02952f
C328 a_4351_10616# a_4351_10404# 0.02952f
C329 a_3967_6160# a_3967_6375# 0.02872f
C330 a_3317_10309# a_2907_10309# 0.14521f
C331 a_1071_4709# RST 0.09224f
C332 a_3009_6967# a_1267_6967# 0.01951f
C333 a_3009_5853# a_2380_5853# 0.01182f
C334 a_1839_5853# a_2380_8081# 0.02197f
C335 VDD a_3009_8603# 0.23443f
C336 a_2584_6967# a_3009_7689# 0.04719f
C337 a_1839_10309# a_1941_9195# 0.01707f
C338 a_4351_9283# a_4351_9495# 0.02952f
C339 a_1479_4709# a_1071_4709# 0.14353f
C340 a_1267_6967# a_917_8508# 0.48204f
C341 a_3521_8081# a_2907_8081# 0.01239f
C342 a_4735_10831# a_4735_11043# 0.02952f
C343 a_2380_8081# a_2907_8081# 0.19723f
C344 VDD a_2584_8081# 0.48033f
C345 a_1839_6967# a_1267_8081# 0.01066f
C346 COMP RST 0.37376f
C347 VDD a_1369_6967# 0.23614f
C348 VDD a_2951_11577# 1.54163f
C349 a_4735_7055# a_4351_7055# 0.01085f
C350 COMP a_2840_5276# 0.40363f
C351 VREF a_917_8508# 0.02133f
C352 VX a_1267_6967# 0.18113f
C353 VDD a_2130_4709# 0.7088f
C354 a_4221_4709# RST 0.10042f
C355 a_971_11441# a_971_11577# 0.29305f
C356 a_2805_5853# a_1267_5853# 0.017f
C357 a_1692_4709# a_1820_4745# 0.1987f
C358 COMP a_1479_4709# 0.03361f
C359 VREF VX 0.12926f
C360 a_538_11753# a_538_11577# 0.03126f
C361 VREF a_1267_9195# 0.03021f
C362 a_2907_10309# a_1839_10309# 0.01075f
C363 a_4070_11577# VDD 0.09241f
C364 a_2584_6967# a_2907_6967# 0.34325f
C365 a_3317_10309# a_1267_10309# 0.01121f
C366 VDD a_538_11753# 0.03013f
C367 VREF a_1839_9195# 0.17487f
C368 a_917_8508# a_1839_10309# 0.03192f
C369 a_4351_7267# a_3521_6967# 0.024f
C370 VDD a_1941_9195# 0.2355f
C371 a_2804_11753# a_3037_11753# 0.01498f
C372 a_3984_11577# a_3837_11577# 0.17314f
C373 a_2805_7689# a_1267_6967# 0.01675f
C374 VDD a_5078_11577# 0.03912f
C375 VDD a_2584_9195# 0.47999f
C376 a_4351_7694# a_4351_7482# 0.02952f
C377 VREF a_1267_10309# 0.01098f
C378 a_4351_6375# a_3521_5853# 0.024f
C379 a_4351_7482# a_3521_6967# 0.02437f
C380 a_4351_9922# a_4351_9710# 0.02952f
C381 COMP a_2584_5853# 0.04263f
C382 a_1839_9195# a_1839_10309# 0.23591f
C383 VDD a_1820_4745# 0.23516f
C384 a_3967_8603# a_3967_8388# 0.02872f
C385 VDD a_3009_6967# 0.23443f
C386 a_5078_11577# a_5078_11753# 0.03126f
C387 VDD a_2907_10309# 0.22104f
C388 VX a_538_11577# 0.0101f
C389 a_2380_10309# a_2584_10309# 0.77156f
C390 VDD a_4351_11043# 0.03358f
C391 VDD a_917_8508# 1.33693f
C392 a_1839_8081# a_2584_8081# 0.20243f
C393 a_1267_10309# a_1839_10309# 0.91449f
C394 a_1003_4745# a_1267_6967# 0.06917f
C395 a_4351_7267# a_4735_7267# 0.01085f
C396 a_3967_7055# a_4351_7055# 0.01085f
C397 a_971_11753# a_885_11577# 0.02034f
C398 a_3317_8081# a_2907_8081# 0.14521f
C399 a_1941_10309# a_1839_10309# 0.1072f
C400 VDD VX 1.09717f
C401 a_3521_10309# MEM 0.10909f
C402 VDD a_4735_7055# 0.02946f
C403 VREF a_1003_4745# 0.45806f
C404 a_4070_11577# a_4070_11441# 0.29305f
C405 VDD a_1267_9195# 0.94965f
C406 a_917_6931# a_1941_9195# 0.01275f
C407 VDD a_1839_9195# 0.74774f
C408 a_3009_10309# a_2380_10309# 0.01182f
C409 VDD a_3037_11933# 0.11627f
C410 a_4351_7267# a_4351_7055# 0.02952f
C411 a_1003_4745# a_1839_10309# 0.81032f
C412 a_1839_5853# a_1267_6967# 0.36249f
C413 a_1839_5853# a_1941_6375# 0.2177f
C414 VREF a_1839_5853# 4.42108f
C415 VDD a_1267_10309# 0.92767f
C416 a_4351_10831# a_3967_10831# 0.01085f
C417 VDD a_3207_4709# 0.54338f
C418 a_3317_9195# a_1267_9195# 0.01067f
C419 a_2907_9195# a_2805_9917# 0.09917f
C420 a_4070_11441# a_4351_11043# 0.01084f
C421 COMP a_2130_4709# 0.32329f
C422 a_917_6931# a_917_8508# 0.04203f
C423 a_3009_10309# a_2584_10309# 0.04714f
C424 a_2907_6967# a_3521_6967# 0.01239f
C425 a_4070_11933# a_4070_11753# 0.12339f
C426 a_4351_6375# a_4351_6587# 0.02952f
C427 a_1839_5853# a_1839_10309# 0.24855f
C428 a_917_6931# VX 0.02072f
C429 a_4351_10616# MEM 0.02627f
C430 a_1267_5853# a_1369_10831# 0.01681f
C431 a_3317_5853# a_3521_5853# 0.40835f
C432 a_4351_6587# a_4735_6587# 0.01085f
C433 a_1839_5853# a_2907_5853# 0.01788f
C434 VDD a_3037_11753# 0.08238f
C435 a_917_6931# a_1267_9195# 0.0289f
C436 a_3967_10404# a_4351_10404# 0.01085f
C437 VDD a_1003_4745# 1.30172f
C438 a_917_6931# a_1839_9195# 0.669f
C439 a_3967_9283# a_3967_9495# 0.02952f
C440 VDD a_3967_7055# 0.03605f
C441 a_2584_8081# a_2805_8603# 0.04511f
C442 a_1839_8081# a_1267_9195# 0.01817f
C443 a_3317_6967# a_2907_6967# 0.14521f
C444 a_1839_8081# a_1839_9195# 0.29002f
C445 a_4351_9495# a_3967_9495# 0.01085f
C446 a_917_6931# a_1267_10309# 0.0112f
C447 a_1369_7689# a_1267_8081# 0.02351f
C448 VDD a_1839_5853# 0.92568f
C449 a_4735_8603# a_4351_8603# 0.01085f
C450 a_2907_5853# a_2805_5853# 0.09917f
C451 VDD a_2907_8081# 0.18912f
C452 a_3521_9195# MEM 0.10908f
C453 a_2769_4709# a_2897_5460# 0.09977f
C454 VDD a_2004_11577# 0.09027f
C455 a_1369_5853# a_1267_5853# 0.09917f
C456 VDD a_4828_5366# 0.60213f
C457 a_917_6931# a_1003_4745# 0.08886f
C458 a_3521_5853# a_3521_6967# 0.03716f
C459 a_1839_5853# a_2380_5853# 0.21826f
C460 a_1941_9917# a_1839_10309# 0.02347f
C461 a_1267_6967# a_2907_6967# 0.37474f
C462 VDD a_5078_11933# 0.03315f
C463 a_1839_9195# a_1941_8081# 0.01613f
C464 a_1839_8081# a_1003_4745# 0.74489f
C465 a_3009_9917# a_2907_9195# 0.09922f
C466 a_3317_5853# a_1267_5853# 0.01123f
C467 a_4070_11753# MEM 0.03551f
C468 a_5078_11933# a_5078_11753# 0.02961f
C469 a_1267_5853# a_3009_6375# 0.02044f
C470 a_2805_6375# a_2584_5853# 0.04511f
C471 a_917_6931# a_1839_5853# 0.45472f
C472 COMP a_3207_4709# 0.21872f
C473 a_4351_10831# a_4735_10831# 0.01085f
C474 a_1941_8603# a_1267_8081# 0.01308f
C475 a_1003_4745# a_1071_4709# 0.41602f
C476 a_1839_8081# a_1839_5853# 0.03581f
C477 a_2907_5853# a_2907_6967# 0.02097f
C478 a_2004_11753# a_2804_11753# 0.01525f
C479 a_1839_6967# a_1003_4745# 1.03908f
C480 VDD a_4735_9283# 0.02946f
C481 a_1267_8081# a_1369_8603# 0.2172f
C482 a_2907_9195# a_2584_9195# 0.33207f
C483 VDD a_4351_9283# 0.02919f
C484 a_2805_9195# a_2584_9195# 0.04511f
C485 VDD a_3837_11577# 0.13722f
C486 a_1839_8081# a_2907_8081# 0.01582f
C487 a_4735_7482# MEM 0.01f
C488 a_2907_9195# a_2907_10309# 0.01112f
C489 a_2805_10309# a_2907_10309# 0.09917f
C490 VX a_538_11441# 0.0108f
C491 a_3545_4709# RST 0.09932f
C492 a_1839_5853# a_1941_5853# 0.10077f
C493 a_1839_6967# a_1839_5853# 0.61597f
C494 a_971_11441# VDD 0.38094f
C495 VDD a_2907_6967# 0.18948f
C496 a_1941_10831# a_1267_10309# 0.01376f
C497 a_2907_9195# a_1267_9195# 0.37517f
C498 a_3521_10309# a_2907_10309# 0.01239f
C499 a_2907_9195# a_1839_9195# 0.01489f
C500 a_3967_6587# a_3967_6375# 0.02952f
C501 a_3521_8081# a_3521_6967# 0.02864f
C502 a_3317_5853# a_3317_6967# 0.01806f
C503 RST SPIKE 0.15213f
C504 a_2584_6967# a_1267_6967# 0.71176f
C505 a_2907_5853# a_3521_5853# 0.01239f
C506 a_2805_10309# a_1267_10309# 0.01675f
C507 a_4828_5366# COMP 0.42881f
C508 a_1479_4709# SPIKE 0.02696f
C509 a_4351_6160# MEM 0.02638f
C510 a_4351_7694# a_3967_7694# 0.01085f
C511 a_1267_6967# a_1369_5853# 0.01488f
C512 a_2907_8081# a_2805_8603# 0.20304f
C513 VDD a_4735_6587# 0.02946f
C514 VDD a_1369_10831# 0.23903f
C515 a_4351_10831# a_3521_10309# 0.024f
C516 a_4735_9283# a_4735_9495# 0.02952f
C517 a_3317_8081# a_2380_8081# 0.0172f
C518 a_3521_8081# a_3317_8081# 0.40835f
C519 a_2951_11577# a_885_11577# 0.10138f
C520 a_2769_4709# RST 0.33204f
C521 a_2840_5276# a_2769_4709# 0.52069f
C522 a_1839_5853# a_1941_10831# 0.01749f
C523 VDD a_3521_5853# 0.73911f
C524 VDD a_2004_11753# 0.08208f
C525 a_3521_8081# a_4351_8388# 0.02437f
C526 a_3967_9283# VDD 0.03605f
C527 a_1267_6967# a_1267_5853# 0.60236f
C528 a_1941_6375# a_1267_5853# 0.01275f
C529 VDD a_971_11577# 0.0921f
C530 VREF a_1267_5853# 0.0768f
C531 a_3317_6967# a_3521_6967# 0.40835f
C532 a_3037_11577# a_2951_11577# 0.05268f
C533 a_1839_5853# a_2380_6967# 0.02132f
C534 a_4351_8815# a_4351_8603# 0.02952f
C535 a_1267_8081# a_2805_8081# 0.01675f
C536 a_2951_11577# a_4070_11753# 0.02034f
C537 a_4735_8603# a_4735_8815# 0.02952f
C538 VDD a_2584_6967# 0.48036f
C539 a_1839_6967# a_2907_6967# 0.01463f
C540 a_2380_10309# a_2907_10309# 0.20088f
C541 a_1369_8081# a_1267_8081# 0.1037f
C542 a_2840_5276# RST 0.05759f
C543 a_2907_9195# a_2907_8081# 0.02097f
C544 a_2907_5853# a_3317_5853# 0.14521f
C545 a_4070_11577# a_4070_11753# 0.13024f
C546 a_1479_4709# RST 0.03868f
C547 VDD a_2380_9195# 0.53707f
C548 a_2907_5853# a_1267_5853# 0.37627f
C549 a_4351_10831# a_4351_10616# 0.02872f
C550 a_2584_9195# a_2584_10309# 0.07395f
C551 a_3521_8081# a_4351_8603# 0.024f
C552 a_2907_5853# a_3009_6375# 0.21534f
C553 a_3317_8081# a_3317_6967# 0.03047f
C554 a_1369_8603# a_917_8508# 0.01479f
C555 a_2907_10309# a_2584_10309# 0.3331f
C556 VX a_885_11577# 0.06845f
C557 a_1369_10309# a_1267_10309# 0.10698f
C558 a_971_11753# VX 0.02483f
C559 VDD a_3984_11577# 0.1367f
C560 VDD a_3317_5853# 0.72715f
C561 a_4735_7694# a_4735_7482# 0.02952f
C562 VDD a_4351_8815# 0.02919f
C563 a_5078_11441# MEM 0.01001f
C564 a_3009_10831# a_2907_10309# 0.21534f
C565 a_2584_8081# a_3009_8081# 0.04719f
C566 VDD a_2538_4709# 0.48507f
C567 a_2130_4709# SPIKE 0.26706f
C568 VDD a_1267_5853# 0.99344f
C569 a_3317_9195# a_2380_9195# 0.0172f
C570 VDD a_3009_6375# 0.23443f
C571 a_1369_8603# a_1267_9195# 0.03168f
C572 a_1267_10309# a_2380_10309# 0.63065f
C573 a_1941_8603# a_1839_9195# 0.02669f
C574 a_2004_11577# a_1918_11577# 0.01534f
C575 VDD a_4351_6587# 0.02919f
C576 a_2380_6967# a_3009_7689# 0.01182f
C577 VDD a_3009_9195# 0.23443f
C578 a_1267_6967# a_3317_6967# 0.01031f
C579 a_3967_8176# a_4351_8176# 0.01085f
C580 a_4735_8388# a_4735_8603# 0.02872f
C581 a_3009_10309# a_2907_10309# 0.0992f
C582 VDD a_3521_8081# 0.73911f
C583 VDD a_2380_8081# 0.53678f
C584 a_3317_5853# a_2380_5853# 0.0172f
C585 a_1267_5853# a_2380_5853# 0.60641f
C586 a_2951_11577# MEM 0.07377f
C587 a_1267_10309# a_2584_10309# 0.678f
C588 COMP a_3521_5853# 0.03736f
C589 a_4351_9495# a_4735_9495# 0.01085f
C590 a_3009_10831# a_1267_10309# 0.02044f
C591 a_2584_8081# a_2805_8081# 0.01463f
C592 a_2380_6967# a_2907_6967# 0.19723f
C593 a_4735_9922# a_4735_9710# 0.02952f
C594 a_3967_6587# a_4351_6587# 0.01085f
C595 a_1839_6967# a_2584_6967# 0.20131f
C596 a_4351_8603# a_4351_8388# 0.02872f
C597 VDD a_3521_6967# 0.73911f
C598 a_1771_11577# a_971_11577# 0.01602f
C599 a_917_6931# a_1267_5853# 0.11624f
C600 a_4351_11043# a_3967_11043# 0.01085f
C601 a_4351_9495# a_4351_9710# 0.02872f
C602 a_1839_5853# a_2380_10309# 0.01728f
C603 a_538_11753# a_538_11933# 0.02961f
C604 a_3009_8603# a_1267_8081# 0.02006f
C605 VREF a_1267_6967# 0.04577f
C606 a_2805_10831# VDD 0.23928f
C607 a_3009_5853# a_2584_5853# 0.04719f
C608 a_3545_4709# a_3207_4709# 0.15107f
C609 a_2130_4709# RST 0.16603f
C610 a_3037_11577# a_3037_11753# 0.13024f
C611 a_4735_6375# a_4735_6160# 0.02872f
C612 a_2584_8081# a_1267_8081# 0.71451f
C613 a_1267_8081# a_1369_6967# 0.01878f
C614 a_2805_6967# a_2907_6967# 0.20304f
C615 a_4735_10616# a_4735_10404# 0.02952f
C616 VDD a_3317_6967# 0.7263f
C617 a_1839_8081# a_2380_8081# 0.20529f
C618 a_1369_6375# a_917_8508# 0.01186f
C619 VDD a_3317_8081# 0.72626f
C620 a_1839_5853# a_2584_10309# 0.01748f
C621 VDD a_2804_11753# 0.09973f
C622 VREF a_1839_10309# 0.18656f
C623 a_1839_6967# a_1267_5853# 0.02944f
C624 SPIKE VSS 0.98309f
C625 RST VSS 0.71214f
C626 COMP VSS 1.54183f
C627 VREF VSS 1.52507f
C628 MEM VSS 6.74434f
C629 VX VSS 2.49523f
C630 VDD VSS 29.1751f
C631 a_1820_4745# VSS 0.01179f
C632 a_2897_5460# VSS 0.1384f
C633 a_4828_5366# VSS 0.71615f
C634 a_4221_4709# VSS 0.58268f
C635 a_3883_4709# VSS 0.57879f
C636 a_3545_4709# VSS 0.57675f
C637 a_3207_4709# VSS 0.57725f
C638 a_2840_5276# VSS 0.27357f
C639 a_2769_4709# VSS 0.23519f
C640 a_2538_4709# VSS 0.48983f
C641 a_2130_4709# VSS 0.71347f
C642 a_1692_4709# VSS 0.45133f
C643 a_1479_4709# VSS 0.49468f
C644 a_1071_4709# VSS 0.75171f
C645 a_4735_5948# VSS 0.23941f $ **FLOATING
C646 a_4351_5948# VSS 0.21737f $ **FLOATING
C647 a_3967_5948# VSS 0.23248f $ **FLOATING
C648 a_3009_5853# VSS 0.13943f
C649 a_2805_5853# VSS 0.14073f
C650 a_1941_5853# VSS 0.14052f
C651 a_1369_5853# VSS 0.14052f
C652 a_4735_6160# VSS 0.19978f $ **FLOATING
C653 a_4351_6160# VSS 0.13383f $ **FLOATING
C654 a_3967_6160# VSS 0.19335f $ **FLOATING
C655 a_4735_6375# VSS 0.19881f $ **FLOATING
C656 a_4351_6375# VSS 0.13338f $ **FLOATING
C657 a_3967_6375# VSS 0.18526f $ **FLOATING
C658 a_4735_6587# VSS 0.19814f $ **FLOATING
C659 a_4351_6587# VSS 0.18434f $ **FLOATING
C660 a_3967_6587# VSS 0.18454f $ **FLOATING
C661 a_3521_5853# VSS 1.00157f
C662 a_3009_6375# VSS 0.01317f
C663 a_2805_6375# VSS 0.01209f
C664 a_1941_6375# VSS 0.01246f
C665 a_1369_6375# VSS 0.0124f
C666 a_3317_5853# VSS 0.75506f
C667 a_2907_5853# VSS 0.31432f
C668 a_2380_5853# VSS 0.55902f
C669 a_2584_5853# VSS 0.50528f
C670 a_4735_7055# VSS 0.19814f $ **FLOATING
C671 a_4351_7055# VSS 0.18434f $ **FLOATING
C672 a_3967_7055# VSS 0.18454f $ **FLOATING
C673 a_4735_7267# VSS 0.19881f $ **FLOATING
C674 a_4351_7267# VSS 0.13338f $ **FLOATING
C675 a_3967_7267# VSS 0.18526f $ **FLOATING
C676 a_3009_6967# VSS 0.01317f
C677 a_2805_6967# VSS 0.01209f
C678 a_1941_6967# VSS 0.0125f
C679 a_1369_6967# VSS 0.01243f
C680 a_4735_7482# VSS 0.19978f $ **FLOATING
C681 a_4351_7482# VSS 0.13383f $ **FLOATING
C682 a_3967_7482# VSS 0.19335f $ **FLOATING
C683 a_4735_7694# VSS 0.23555f $ **FLOATING
C684 a_4351_7694# VSS 0.21265f $ **FLOATING
C685 a_3967_7694# VSS 0.22917f $ **FLOATING
C686 a_3521_6967# VSS 1.01128f
C687 a_3009_7689# VSS 0.13943f
C688 a_2805_7689# VSS 0.14073f
C689 a_1941_7689# VSS 0.14052f
C690 a_1369_7689# VSS 0.14052f
C691 a_3317_6967# VSS 0.75262f
C692 a_2907_6967# VSS 0.31951f
C693 a_2380_6967# VSS 0.55067f
C694 a_2584_6967# VSS 0.49319f
C695 a_1267_6967# VSS 0.88013f
C696 a_1839_6967# VSS 0.81761f
C697 a_4735_8176# VSS 0.23555f $ **FLOATING
C698 a_4351_8176# VSS 0.21265f $ **FLOATING
C699 a_3967_8176# VSS 0.22917f $ **FLOATING
C700 a_3009_8081# VSS 0.13943f
C701 a_2805_8081# VSS 0.14073f
C702 a_1941_8081# VSS 0.14052f
C703 a_1369_8081# VSS 0.14052f
C704 a_4735_8388# VSS 0.19978f $ **FLOATING
C705 a_4351_8388# VSS 0.13383f $ **FLOATING
C706 a_3967_8388# VSS 0.19335f $ **FLOATING
C707 a_4735_8603# VSS 0.19881f $ **FLOATING
C708 a_4351_8603# VSS 0.13338f $ **FLOATING
C709 a_3967_8603# VSS 0.18526f $ **FLOATING
C710 a_4735_8815# VSS 0.19814f $ **FLOATING
C711 a_4351_8815# VSS 0.18434f $ **FLOATING
C712 a_3967_8815# VSS 0.18454f $ **FLOATING
C713 a_3521_8081# VSS 1.01128f
C714 a_3009_8603# VSS 0.01317f
C715 a_2805_8603# VSS 0.01209f
C716 a_1941_8603# VSS 0.01246f
C717 a_1369_8603# VSS 0.01232f
C718 a_3317_8081# VSS 0.75262f
C719 a_2907_8081# VSS 0.319f
C720 a_2380_8081# VSS 0.55053f
C721 a_2584_8081# VSS 0.49311f
C722 a_1267_8081# VSS 0.86609f
C723 a_1839_8081# VSS 0.81729f
C724 a_4735_9283# VSS 0.19814f $ **FLOATING
C725 a_4351_9283# VSS 0.18434f $ **FLOATING
C726 a_3967_9283# VSS 0.18454f $ **FLOATING
C727 a_4735_9495# VSS 0.19881f $ **FLOATING
C728 a_4351_9495# VSS 0.13338f $ **FLOATING
C729 a_3967_9495# VSS 0.18526f $ **FLOATING
C730 a_3009_9195# VSS 0.01317f
C731 a_2805_9195# VSS 0.01209f
C732 a_1941_9195# VSS 0.0125f
C733 a_1369_9195# VSS 0.0125f
C734 a_4735_9710# VSS 0.19978f $ **FLOATING
C735 a_4351_9710# VSS 0.13383f $ **FLOATING
C736 a_3967_9710# VSS 0.19335f $ **FLOATING
C737 a_4735_9922# VSS 0.23555f $ **FLOATING
C738 a_4351_9922# VSS 0.21265f $ **FLOATING
C739 a_3967_9922# VSS 0.22917f $ **FLOATING
C740 a_3521_9195# VSS 1.01128f
C741 a_3009_9917# VSS 0.13943f
C742 a_2805_9917# VSS 0.14073f
C743 a_1941_9917# VSS 0.14052f
C744 a_1369_9917# VSS 0.14052f
C745 a_3317_9195# VSS 0.75262f
C746 a_2907_9195# VSS 0.32051f
C747 a_2380_9195# VSS 0.55169f
C748 a_2584_9195# VSS 0.49286f
C749 a_1267_9195# VSS 0.90307f
C750 a_1839_9195# VSS 0.81023f
C751 a_4735_10404# VSS 0.23555f $ **FLOATING
C752 a_4351_10404# VSS 0.21265f $ **FLOATING
C753 a_3967_10404# VSS 0.22917f $ **FLOATING
C754 a_3009_10309# VSS 0.13943f
C755 a_2805_10309# VSS 0.14073f
C756 a_1941_10309# VSS 0.14052f
C757 a_1369_10309# VSS 0.14052f
C758 a_4735_10616# VSS 0.19978f $ **FLOATING
C759 a_4351_10616# VSS 0.13383f $ **FLOATING
C760 a_3967_10616# VSS 0.19335f $ **FLOATING
C761 a_1003_4745# VSS 3.07963f
C762 a_4735_10831# VSS 0.19881f $ **FLOATING
C763 a_4351_10831# VSS 0.13338f $ **FLOATING
C764 a_3967_10831# VSS 0.18526f $ **FLOATING
C765 a_4735_11043# VSS 0.1975f $ **FLOATING
C766 a_4351_11043# VSS 0.18183f $ **FLOATING
C767 a_3967_11043# VSS 0.18291f $ **FLOATING
C768 a_3521_10309# VSS 0.99824f
C769 a_3009_10831# VSS 0.01317f
C770 a_2805_10831# VSS 0.01209f
C771 a_1941_10831# VSS 0.0125f
C772 a_1369_10831# VSS 0.0125f
C773 a_3317_10309# VSS 0.75182f
C774 a_2907_10309# VSS 0.32148f
C775 a_2380_10309# VSS 0.55413f
C776 a_2584_10309# VSS 0.49546f
C777 a_1267_10309# VSS 0.94334f
C778 a_1839_10309# VSS 0.84979f
C779 a_917_6931# VSS 0.72918f
C780 a_1839_5853# VSS 1.08423f
C781 a_917_8508# VSS 0.63958f
C782 a_1267_5853# VSS 0.98091f
C783 a_5078_11441# VSS 0.09026f $ **FLOATING
C784 a_4070_11441# VSS 0.2769f $ **FLOATING
C785 a_3037_11441# VSS 0.25473f $ **FLOATING
C786 a_2004_11441# VSS 0.25733f $ **FLOATING
C787 a_971_11441# VSS 0.25753f $ **FLOATING
C788 a_538_11441# VSS 0.09315f $ **FLOATING
C789 a_5078_11577# VSS 0.06623f $ **FLOATING
C790 a_4070_11577# VSS 0.27596f $ **FLOATING
C791 a_3037_11577# VSS 0.27596f $ **FLOATING
C792 a_2951_11577# VSS 0.15692f
C793 a_2004_11577# VSS 0.27596f $ **FLOATING
C794 a_971_11577# VSS 0.27596f $ **FLOATING
C795 a_885_11577# VSS 0.16175f
C796 a_538_11577# VSS 0.06623f $ **FLOATING
C797 a_5078_11753# VSS 0.07454f $ **FLOATING
C798 a_4070_11753# VSS 0.3106f $ **FLOATING
C799 a_3984_11577# VSS 0.09969f
C800 a_3837_11577# VSS 0.09956f
C801 a_3037_11753# VSS 0.3106f $ **FLOATING
C802 a_2804_11753# VSS 0.11262f
C803 a_2004_11753# VSS 0.3106f $ **FLOATING
C804 a_1918_11577# VSS 0.09917f
C805 a_1771_11577# VSS 0.10041f
C806 a_971_11753# VSS 0.3106f $ **FLOATING
C807 a_538_11753# VSS 0.07454f $ **FLOATING
C808 a_5078_11933# VSS 0.10134f $ **FLOATING
C809 a_4070_11933# VSS 0.42223f $ **FLOATING
C810 a_3037_11933# VSS 0.42223f $ **FLOATING
C811 a_2004_11933# VSS 0.42223f $ **FLOATING
C812 a_971_11933# VSS 0.42223f $ **FLOATING
C813 a_538_11933# VSS 0.10134f $ **FLOATING
.ends
