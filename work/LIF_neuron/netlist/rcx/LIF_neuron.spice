* PEX produced on Sun Mar 22 05:10:43 PM CET 2026 using /foss/tools/sak/sak-pex.sh with m=3 and s=1
* NGSPICE file created from LIF_neuron.ext - technology: ihp-sg13g2

.subckt LIF_neuron VDD Vx MEM RST SPIKE VSS Vref COMP
X0 VSS.t95 VSS.t96 VSS.t46 rppd l=0.5u w=0.5u
X1 VSS.t6 a_2538_4709.t2 a_2130_4709.t1 VSS.t5 sg13_lv_nmos ad=0.34p pd=2.68u as=0.34p ps=2.68u w=1u l=0.13u
X2 a_3521_9195.t3 a_3317_9195.t3 VSS.t207 VSS.t203 sg13_lv_nmos ad=0.19p pd=1.38u as=0.34p ps=2.68u w=1u l=0.13u
X3 VDD.t125 a_1071_4709.t3 a_1003_4745.t0 VDD.t4 sg13_lv_pmos ad=0.38p pd=2.38u as=0.68p ps=4.68u w=2u l=0.13u
X4 VSS.t35 a_2769_4709.t2 a_2538_4709.t1 VSS.t34 sg13_lv_nmos ad=0.19p pd=1.38u as=0.34p ps=2.68u w=1u l=0.13u
X5 VSS.t178 a_2130_4709.t3 SPIKE.t2 VSS.t177 sg13_lv_nmos ad=0.19p pd=1.38u as=0.34p ps=2.68u w=1u l=0.13u
X6 a_3521_6967.t4 a_3317_6967.t2 VSS.t151 VSS.t13 sg13_lv_nmos ad=0.34p pd=2.68u as=0.19p ps=1.38u w=1u l=0.13u
X7 VSS.t229 a_3545_4709.t2 a_3207_4709.t1 VSS.t197 sg13_lv_nmos ad=0.34p pd=2.68u as=0.34p ps=2.68u w=1u l=0.65u
X8 VSS.t105 VSS.t106 VSS.t46 rppd l=0.5u w=0.5u
X9 VSS.t72 VSS.t73 VSS.t71 rppd l=0.5u w=0.5u
X10 a_1369_6967.t0 a_1267_8081.t2 a_1267_6967.t0 VDD.t9 sg13_lv_pmos ad=0.38p pd=2.38u as=0.38p ps=2.38u w=2u l=0.13u
X11 VDD.t74 VDD.t75 VSS.t89 rhigh l=0.96u w=0.5u
X12 VDD.t73 a_917_8508.t6 a_1369_9195.t0 VDD.t1 sg13_lv_pmos ad=0.68p pd=4.68u as=0.38p ps=2.38u w=2u l=0.13u
X13 a_3317_6967.t1 a_2907_6967.t2 VSS.t153 VSS.t111 sg13_lv_nmos ad=0.34p pd=2.68u as=0.34p ps=2.68u w=1u l=0.13u
X14 a_2907_6967.t1 a_2584_6967.t2 a_2805_6967.t0 VDD.t9 sg13_lv_pmos ad=0.38p pd=2.38u as=0.38p ps=2.38u w=2u l=0.13u
X15 a_2907_10309.t0 a_2584_10309.t3 a_2805_10831.t0 VDD.t0 sg13_lv_pmos ad=0.38p pd=2.38u as=0.38p ps=2.38u w=2u l=0.13u
X16 a_1369_10309.t0 a_1267_5853.t5 a_1267_10309.t1 VSS.t70 sg13_lv_nmos ad=0.19p pd=1.38u as=0.19p ps=1.38u w=1u l=0.13u
X17 a_3009_9195.t0 a_1267_9195.t3 a_2907_9195.t0 VDD.t1 sg13_lv_pmos ad=0.38p pd=2.38u as=0.38p ps=2.38u w=2u l=0.13u
X18 a_1839_8081.t0 VDD.t48 VDD.t49 VDD.t1 sg13_lv_pmos ad=0.38p pd=2.38u as=0.68p ps=4.68u w=2u l=0.13u
X19 a_1267_5853.t0 a_1003_4745.t5 VSS.t110 VSS.t109 sg13_lv_nmos ad=0.19p pd=1.38u as=0.34p ps=2.68u w=1u l=0.13u
X20 a_3521_8081.t4 MEM.t8 VSS.t7 rppd l=0.5u w=0.5u
X21 a_1369_8081.t0 a_1267_9195.t2 a_1267_8081.t1 VSS.t3 sg13_lv_nmos ad=0.19p pd=1.38u as=0.19p ps=1.38u w=1u l=0.13u
X22 VDD.t44 COMP.t2 a_4221_4709.t0 VDD.t4 sg13_lv_pmos ad=0.68p pd=4.68u as=0.68p ps=4.68u w=2u l=0.65u
X23 VDD.t108 a_3883_4709.t2 a_3545_4709.t0 VDD.t4 sg13_lv_pmos ad=0.68p pd=4.68u as=0.68p ps=4.68u w=2u l=0.65u
X24 a_2907_8081.t1 a_1267_8081.t3 a_2805_8081.t0 VSS.t68 sg13_lv_nmos ad=0.19p pd=1.38u as=0.19p ps=1.38u w=1u l=0.13u
X25 VSS.t78 RST.t0 a_1692_4709.t1 VSS.t77 sg13_lv_nmos ad=0.34p pd=2.68u as=0.19p ps=1.38u w=1u l=0.13u
X26 VSS.t244 VSS.t245 VSS.t24 rppd l=0.5u w=0.5u
X27 VSS.t131 a_4828_5366.t2 COMP.t0 VSS.t130 sg13_lv_nmos ad=0.19p pd=1.38u as=0.19p ps=1.38u w=1u l=0.13u
X28 a_3521_10309.t4 a_3317_10309.t3 VSS.t204 VSS.t203 sg13_lv_nmos ad=0.19p pd=1.38u as=0.34p ps=2.68u w=1u l=0.13u
X29 a_3521_6967.t3 a_3317_6967.t2 VDD.t78 VDD.t9 sg13_lv_pmos ad=0.68p pd=4.68u as=0.38p ps=2.38u w=2u l=0.13u
X30 VSS.t8 VSS.t9 VSS.t7 rppd l=0.5u w=0.5u
X31 a_2584_10309.t1 a_1267_10309.t4 VSS.t30 VSS.t29 sg13_lv_nmos ad=0.34p pd=2.68u as=0.34p ps=2.68u w=1u l=0.13u
X32 VDD.t5 a_2538_4709.t2 a_2130_4709.t0 VDD.t4 sg13_lv_pmos ad=0.68p pd=4.68u as=0.68p ps=4.68u w=2u l=0.13u
X33 VSS.t113 VSS.t114 VSS.t49 rppd l=0.5u w=0.5u
X34 a_3317_6967.t0 a_2907_6967.t2 VDD.t82 VDD.t9 sg13_lv_pmos ad=0.68p pd=4.68u as=0.68p ps=4.68u w=2u l=0.13u
X35 VSS.t198 a_3317_5853.t2 a_3521_5853.t2 VSS.t197 sg13_lv_nmos ad=0.19p pd=1.38u as=0.19p ps=1.38u w=1u l=0.13u
X36 a_1839_9195.t1 VSS.t165 VSS.t167 VSS.t166 sg13_lv_nmos ad=0.19p pd=1.38u as=0.34p ps=2.68u w=1u l=0.13u
X37 a_3521_8081.t3 a_3317_8081.t2 VSS.t12 VSS.t13 sg13_lv_nmos ad=0.34p pd=2.68u as=0.19p ps=1.38u w=1u l=0.13u
X38 VDD.t89 a_2130_4709.t3 SPIKE.t3 VDD.t4 sg13_lv_pmos ad=0.38p pd=2.38u as=0.68p ps=4.68u w=2u l=0.13u
X39 a_1267_8081.t0 VDD.t54 VDD.t55 VDD.t1 sg13_lv_pmos ad=0.38p pd=2.38u as=0.68p ps=4.68u w=2u l=0.13u
X40 a_2805_10309.t0 a_1839_10309.t3 VSS.t138 VSS.t44 sg13_lv_nmos ad=0.19p pd=1.38u as=0.34p ps=2.68u w=1u l=0.13u
X41 a_1003_4745.t3 a_1071_4709.t3 VSS.t249 VSS.t250 sg13_lv_nmos ad=0.19p pd=1.38u as=0.19p ps=1.38u w=1u l=0.13u
X42 VSS.t94 a_2380_5853.t2 a_3009_5853.t0 VSS.t93 sg13_lv_nmos ad=0.34p pd=2.68u as=0.19p ps=1.38u w=1u l=0.13u
X43 a_3317_8081.t1 a_2907_8081.t2 VSS.t112 VSS.t111 sg13_lv_nmos ad=0.34p pd=2.68u as=0.34p ps=2.68u w=1u l=0.13u
X44 a_2584_5853.t1 a_1267_5853.t3 VSS.t218 VSS.t217 sg13_lv_nmos ad=0.34p pd=2.68u as=0.34p ps=2.68u w=1u l=0.13u
X45 VSS.t145 VSS.t146 VSS.t90 rppd l=0.5u w=0.5u
X46 VDD.t47 a_917_8508.t3 a_1369_6375.t0 VDD.t9 sg13_lv_pmos ad=0.68p pd=4.68u as=0.38p ps=2.38u w=2u l=0.13u
X47 VSS.t50 VSS.t51 VSS.t49 rppd l=0.5u w=0.5u
X48 a_2380_9195.t0 a_1839_9195.t4 VDD.t25 VDD.t1 sg13_lv_pmos ad=0.68p pd=4.68u as=0.68p ps=4.68u w=2u l=0.13u
X49 a_3009_6375.t0 a_1267_5853.t4 a_2907_5853.t1 VDD.t9 sg13_lv_pmos ad=0.38p pd=2.38u as=0.38p ps=2.38u w=2u l=0.13u
X50 VSS.t161 VSS.t162 VSS.t46 rppd l=0.5u w=0.5u
X51 a_1839_10309.t1 VDD.t60 VDD.t61 VDD.t0 sg13_lv_pmos ad=0.38p pd=2.38u as=0.68p ps=4.68u w=2u l=0.13u
X52 VSS.t239 MEM.t11 a_4828_5366.t1 VSS.t238 sg13_lv_nmos ad=0.34p pd=2.68u as=0.19p ps=1.38u w=1u l=0.13u
X53 VSS.t159 VSS.t160 VSS.t52 rppd l=0.5u w=0.5u
X54 VDD.t6 a_3317_8081.t2 a_3521_8081.t0 VDD.t1 sg13_lv_pmos ad=0.38p pd=2.38u as=0.38p ps=2.38u w=2u l=0.13u
X55 a_1692_4709.t0 RST.t0 a_1820_4745.t0 VDD.t4 sg13_lv_pmos ad=0.68p pd=4.68u as=0.38p ps=2.38u w=2u l=0.13u
X56 a_1267_9195.t0 VSS.t170 VSS.t172 VSS.t171 sg13_lv_nmos ad=0.19p pd=1.38u as=0.34p ps=2.68u w=1u l=0.13u
X57 VSS.t53 VSS.t54 VSS.t52 rppd l=0.5u w=0.5u
X58 a_2907_10309.t1 a_1267_10309.t3 a_2805_10309.t0 VSS.t176 sg13_lv_nmos ad=0.19p pd=1.38u as=0.19p ps=1.38u w=1u l=0.13u
X59 VSS.t79 VSS.t80 VSS.t41 rppd l=0.5u w=0.5u
X60 VDD.t72 a_917_8508.t7 a_1369_10831.t0 VDD.t0 sg13_lv_pmos ad=0.68p pd=4.68u as=0.38p ps=2.38u w=2u l=0.13u
X61 VSS.t254 VX.t2 a_1369_7689.t0 VSS.t253 sg13_lv_nmos ad=0.34p pd=2.68u as=0.19p ps=1.38u w=1u l=0.13u
X62 VDD.t128 a_2380_8081.t2 a_3009_8603.t0 VDD.t1 sg13_lv_pmos ad=0.68p pd=4.68u as=0.38p ps=2.38u w=2u l=0.13u
X63 VDD.t42 COMP.t3 a_2769_4709.t0 VDD.t4 sg13_lv_pmos ad=0.68p pd=4.68u as=0.38p ps=2.38u w=2u l=0.13u
X64 a_2584_8081.t0 a_1267_8081.t4 VDD.t35 VDD.t1 sg13_lv_pmos ad=0.68p pd=4.68u as=0.68p ps=4.68u w=2u l=0.13u
X65 a_3009_7689.t0 a_2584_6967.t3 a_2907_6967.t0 VSS.t55 sg13_lv_nmos ad=0.19p pd=1.38u as=0.19p ps=1.38u w=1u l=0.13u
X66 VDD.t80 VDD.t81 VSS.t89 rhigh l=0.96u w=0.5u
X67 a_3521_8081.t5 MEM.t9 VSS.t7 rppd l=0.5u w=0.5u
X68 a_1941_5853.t0 a_1839_6967.t2 a_1839_5853.t0 VSS.t212 sg13_lv_nmos ad=0.19p pd=1.38u as=0.19p ps=1.38u w=1u l=0.13u
X69 VSS.t241 a_3317_9195.t2 a_3521_9195.t3 VSS.t156 sg13_lv_nmos ad=0.19p pd=1.38u as=0.19p ps=1.38u w=1u l=0.13u
X70 a_917_8508.t1 a_917_8508.t0 VDD.t88 VDD.t1 sg13_lv_pmos ad=0.68p pd=4.68u as=0.68p ps=4.68u w=2u l=0.13u
X71 a_1003_4745.t1 a_1071_4709.t3 VDD.t125 VDD.t4 sg13_lv_pmos ad=0.38p pd=2.38u as=0.38p ps=2.38u w=2u l=0.13u
X72 SPIKE.t0 a_2130_4709.t3 VSS.t178 VSS.t179 sg13_lv_nmos ad=0.19p pd=1.38u as=0.19p ps=1.38u w=1u l=0.13u
X73 a_2380_5853.t0 a_1839_5853.t3 VDD.t96 VDD.t9 sg13_lv_pmos ad=0.68p pd=4.68u as=0.68p ps=4.68u w=2u l=0.13u
X74 VDD.t84 a_3317_10309.t2 a_3521_10309.t2 VDD.t0 sg13_lv_pmos ad=0.38p pd=2.38u as=0.38p ps=2.38u w=2u l=0.13u
X75 a_2584_9195.t1 a_1267_9195.t4 VSS.t74 VSS.t29 sg13_lv_nmos ad=0.34p pd=2.68u as=0.34p ps=2.68u w=1u l=0.13u
X76 VSS.t121 a_2380_9195.t2 a_3009_9917.t0 VSS.t101 sg13_lv_nmos ad=0.34p pd=2.68u as=0.19p ps=1.38u w=1u l=0.13u
X77 VSS.t83 VSS.t84 VSS.t71 rppd l=0.5u w=0.5u
X78 VSS.t261 VSS.t262 VSS.t24 rppd l=0.5u w=0.5u
X79 VDD.t129 VDD.t130 VSS.t36 rhigh l=4u w=0.5u
X80 VDD.t26 a_917_8508.t4 a_1369_6967.t0 VDD.t9 sg13_lv_pmos ad=0.68p pd=4.68u as=0.38p ps=2.38u w=2u l=0.13u
X81 a_2804_11753.t0 a_3837_11577.t0 VSS.t36 rhigh l=4u w=0.5u
X82 a_3009_6967.t0 a_1267_6967.t3 a_2907_6967.t1 VDD.t9 sg13_lv_pmos ad=0.38p pd=2.38u as=0.38p ps=2.38u w=2u l=0.13u
X83 VSS.t164 a_4221_4709.t2 a_3883_4709.t1 VSS.t163 sg13_lv_nmos ad=0.34p pd=2.68u as=0.34p ps=2.68u w=1u l=0.65u
X84 a_1918_11577.t0 a_885_11577.t0 VSS.t69 rhigh l=4u w=0.5u
X85 VSS.t227 VSS.t228 VSS.t52 rppd l=0.5u w=0.5u
X86 a_2805_9195.t0 a_1839_9195.t3 VDD.t16 VDD.t1 sg13_lv_pmos ad=0.38p pd=2.38u as=0.68p ps=4.68u w=2u l=0.13u
X87 a_1941_8603.t0 a_1839_9195.t2 a_1839_8081.t0 VDD.t1 sg13_lv_pmos ad=0.38p pd=2.38u as=0.38p ps=2.38u w=2u l=0.13u
X88 a_1369_5853.t0 a_1267_6967.t2 a_1267_5853.t0 VSS.t58 sg13_lv_nmos ad=0.19p pd=1.38u as=0.19p ps=1.38u w=1u l=0.13u
X89 VDD.t8 a_917_6931.t6 a_1941_9195.t0 VDD.t1 sg13_lv_pmos ad=0.68p pd=4.68u as=0.38p ps=2.38u w=2u l=0.13u
X90 VSS.t257 VX.t3 a_1369_8081.t0 VSS.t253 sg13_lv_nmos ad=0.34p pd=2.68u as=0.19p ps=1.38u w=1u l=0.13u
X91 a_2907_5853.t0 a_1267_5853.t2 a_2805_5853.t0 VSS.t182 sg13_lv_nmos ad=0.19p pd=1.38u as=0.19p ps=1.38u w=1u l=0.13u
X92 a_3009_8081.t0 a_2584_8081.t2 a_2907_8081.t1 VSS.t55 sg13_lv_nmos ad=0.19p pd=1.38u as=0.19p ps=1.38u w=1u l=0.13u
X93 a_2380_6967.t1 a_1839_6967.t4 VSS.t147 VSS.t128 sg13_lv_nmos ad=0.34p pd=2.68u as=0.34p ps=2.68u w=1u l=0.13u
X94 VSS.t117 VSS.t118 VSS.t41 rppd l=0.5u w=0.5u
X95 a_3317_10309.t0 a_2907_10309.t2 VDD.t69 VDD.t0 sg13_lv_pmos ad=0.68p pd=4.68u as=0.68p ps=4.68u w=2u l=0.13u
X96 a_1839_10309.t0 a_1003_4745.t8 VSS.t240 VSS.t166 sg13_lv_nmos ad=0.19p pd=1.38u as=0.34p ps=2.68u w=1u l=0.13u
X97 VDD.t94 VDD.t95 VSS.t31 rhigh l=0.96u w=0.5u
X98 a_2380_10309.t0 a_1839_10309.t4 VDD.t105 VDD.t0 sg13_lv_pmos ad=0.68p pd=4.68u as=0.68p ps=4.68u w=2u l=0.13u
X99 VSS.t205 VSS.t206 VSS.t0 rppd l=0.5u w=0.5u
X100 a_3009_10831.t0 a_1267_10309.t5 a_2907_10309.t0 VDD.t0 sg13_lv_pmos ad=0.38p pd=2.38u as=0.38p ps=2.38u w=2u l=0.13u
X101 VSS.t256 VX.t6 a_1369_10309.t0 VSS.t251 sg13_lv_nmos ad=0.34p pd=2.68u as=0.19p ps=1.38u w=1u l=0.13u
X102 a_1941_9917.t0 a_1839_10309.t2 a_1839_9195.t1 VSS.t136 sg13_lv_nmos ad=0.19p pd=1.38u as=0.19p ps=1.38u w=1u l=0.13u
X103 a_3521_9195.t2 a_3317_9195.t3 VDD.t104 VDD.t1 sg13_lv_pmos ad=0.38p pd=2.38u as=0.68p ps=4.68u w=2u l=0.13u
X104 VSS.t208 VSS.t209 VSS.t52 rppd l=0.5u w=0.5u
X105 SPIKE.t1 a_2130_4709.t3 VDD.t89 VDD.t4 sg13_lv_pmos ad=0.38p pd=2.38u as=0.38p ps=2.38u w=2u l=0.13u
X106 a_3521_5853.t4 a_3317_5853.t2 VSS.t198 VSS.t199 sg13_lv_nmos ad=0.34p pd=2.68u as=0.19p ps=1.38u w=1u l=0.13u
X107 a_1369_8603.t0 a_1267_9195.t2 a_1267_8081.t0 VDD.t1 sg13_lv_pmos ad=0.38p pd=2.38u as=0.38p ps=2.38u w=2u l=0.13u
X108 VSS.t193 VSS.t194 VSS.t52 rppd l=0.5u w=0.5u
X109 a_3317_5853.t1 a_2907_5853.t2 VSS.t140 VSS.t139 sg13_lv_nmos ad=0.34p pd=2.68u as=0.34p ps=2.68u w=1u l=0.13u
X110 VDD.t99 VDD.t100 VSS.t39 rhigh l=4u w=0.5u
X111 a_3984_11577.t0 MEM.t0 VSS.t39 rhigh l=4u w=0.5u
X112 a_2907_8081.t0 a_2584_8081.t3 a_2805_8603.t0 VDD.t1 sg13_lv_pmos ad=0.38p pd=2.38u as=0.38p ps=2.38u w=2u l=0.13u
X113 VSS.t226 a_1071_4709.t2 a_1003_4745.t3 VSS.t225 sg13_lv_nmos ad=0.34p pd=2.68u as=0.19p ps=1.38u w=1u l=0.13u
X114 a_3521_9195.t0 MEM.t5 VSS.t49 rppd l=0.5u w=0.5u
X115 a_2380_6967.t0 a_1839_6967.t4 VDD.t76 VDD.t9 sg13_lv_pmos ad=0.68p pd=4.68u as=0.68p ps=4.68u w=2u l=0.13u
X116 VSS.t232 VSS.t233 VSS.t90 rppd l=0.5u w=0.5u
X117 VSS.t157 a_3317_10309.t2 a_3521_10309.t4 VSS.t156 sg13_lv_nmos ad=0.19p pd=1.38u as=0.19p ps=1.38u w=1u l=0.13u
X118 VSS.t185 VSS.t186 VSS.t46 rppd l=0.5u w=0.5u
X119 a_2805_6375.t0 a_1839_5853.t2 VDD.t39 VDD.t9 sg13_lv_pmos ad=0.38p pd=2.38u as=0.68p ps=4.68u w=2u l=0.13u
X120 a_2380_8081.t1 a_1839_8081.t4 VSS.t129 VSS.t128 sg13_lv_nmos ad=0.34p pd=2.68u as=0.34p ps=2.68u w=1u l=0.13u
X121 VSS.t42 VSS.t43 VSS.t41 rppd l=0.5u w=0.5u
X122 VDD.t68 a_917_6931.t3 a_1941_6375.t0 VDD.t9 sg13_lv_pmos ad=0.68p pd=4.68u as=0.38p ps=2.38u w=2u l=0.13u
X123 VSS.t103 VSS.t104 VSS.t24 rppd l=0.5u w=0.5u
X124 VDD.t106 VDD.t107 VSS.t4 rhigh l=4u w=0.5u
X125 VX.t0 a_1771_11577.t0 VSS.t4 rhigh l=4u w=0.5u
X126 a_1369_9917.t0 a_1267_10309.t2 a_1267_9195.t0 VSS.t70 sg13_lv_nmos ad=0.19p pd=1.38u as=0.19p ps=1.38u w=1u l=0.13u
X127 a_3521_8081.t1 a_3317_8081.t2 VDD.t6 VDD.t1 sg13_lv_pmos ad=0.68p pd=4.68u as=0.38p ps=2.38u w=2u l=0.13u
X128 VSS.t67 a_3207_4709.t2 a_2840_5276.t1 VSS.t66 sg13_lv_nmos ad=0.34p pd=2.68u as=0.34p ps=2.68u w=1u l=0.65u
X129 a_2907_9195.t1 a_1267_9195.t5 a_2805_9917.t0 VSS.t176 sg13_lv_nmos ad=0.19p pd=1.38u as=0.19p ps=1.38u w=1u l=0.13u
X130 a_3317_8081.t0 a_2907_8081.t2 VDD.t34 VDD.t1 sg13_lv_pmos ad=0.68p pd=4.68u as=0.68p ps=4.68u w=2u l=0.13u
X131 VSS.t25 VSS.t26 VSS.t24 rppd l=0.5u w=0.5u
X132 VDD.t15 a_2769_4709.t2 a_2538_4709.t0 VDD.t4 sg13_lv_pmos ad=0.38p pd=2.38u as=0.68p ps=4.68u w=2u l=0.13u
X133 a_2805_7689.t0 a_1839_6967.t3 VSS.t100 VSS.t99 sg13_lv_nmos ad=0.19p pd=1.38u as=0.34p ps=2.68u w=1u l=0.13u
X134 a_3521_5853.t1 a_3317_5853.t3 VDD.t19 VDD.t9 sg13_lv_pmos ad=0.38p pd=2.38u as=0.68p ps=4.68u w=2u l=0.13u
X135 a_1941_10831.t0 a_1839_5853.t4 a_1839_10309.t1 VDD.t0 sg13_lv_pmos ad=0.38p pd=2.38u as=0.38p ps=2.38u w=2u l=0.13u
X136 a_3317_10309.t1 a_2907_10309.t2 VSS.t137 VSS.t119 sg13_lv_nmos ad=0.34p pd=2.68u as=0.34p ps=2.68u w=1u l=0.13u
X137 a_1839_9195.t0 VDD.t64 VDD.t65 VDD.t1 sg13_lv_pmos ad=0.38p pd=2.38u as=0.68p ps=4.68u w=2u l=0.13u
X138 VSS.t64 VSS.t65 VSS.t7 rppd l=0.5u w=0.5u
X139 VSS.t18 VREF.t1 a_1941_7689.t0 VSS.t14 sg13_lv_nmos ad=0.34p pd=2.68u as=0.19p ps=1.38u w=1u l=0.13u
X140 VSS.t122 VSS.t123 VSS.t71 rppd l=0.5u w=0.5u
X141 VDD.t114 a_3545_4709.t2 a_3207_4709.t0 VDD.t4 sg13_lv_pmos ad=0.68p pd=4.68u as=0.68p ps=4.68u w=2u l=0.65u
X142 VDD.t117 VDD.t118 VSS.t69 rhigh l=4u w=0.5u
X143 a_2380_10309.t1 a_1839_10309.t4 VSS.t210 VSS.t85 sg13_lv_nmos ad=0.34p pd=2.68u as=0.34p ps=2.68u w=1u l=0.13u
X144 a_3521_9195.t5 a_3317_9195.t2 VSS.t241 VSS.t158 sg13_lv_nmos ad=0.34p pd=2.68u as=0.19p ps=1.38u w=1u l=0.13u
X145 VDD.t113 a_1071_4709.t2 a_1003_4745.t1 VDD.t4 sg13_lv_pmos ad=0.68p pd=4.68u as=0.38p ps=2.38u w=2u l=0.13u
X146 VSS.t108 a_2130_4709.t2 SPIKE.t0 VSS.t107 sg13_lv_nmos ad=0.34p pd=2.68u as=0.19p ps=1.38u w=1u l=0.13u
X147 a_3009_10309.t0 a_2584_10309.t2 a_2907_10309.t1 VSS.t10 sg13_lv_nmos ad=0.19p pd=1.38u as=0.19p ps=1.38u w=1u l=0.13u
X148 a_3317_9195.t1 a_2907_9195.t2 VSS.t120 VSS.t119 sg13_lv_nmos ad=0.34p pd=2.68u as=0.34p ps=2.68u w=1u l=0.13u
X149 VSS.t91 VSS.t92 VSS.t90 rppd l=0.5u w=0.5u
X150 a_2897_5460.t0 a_2840_5276.t2 VSS.t35 VSS.t260 sg13_lv_nmos ad=0.19p pd=1.38u as=0.19p ps=1.38u w=1u l=0.13u
X151 VDD.t111 VDD.t112 VSS.t31 rhigh l=0.96u w=0.5u
X152 VSS.t143 VSS.t144 VSS.t24 rppd l=0.5u w=0.5u
X153 a_3521_6967.t2 a_3317_6967.t3 VSS.t150 VSS.t75 sg13_lv_nmos ad=0.19p pd=1.38u as=0.34p ps=2.68u w=1u l=0.13u
X154 a_2805_6967.t0 a_1839_6967.t3 VDD.t31 VDD.t9 sg13_lv_pmos ad=0.38p pd=2.38u as=0.68p ps=4.68u w=2u l=0.13u
X155 VSS.t221 VSS.t222 VSS.t52 rppd l=0.5u w=0.5u
X156 a_1267_9195.t1 VDD.t56 VDD.t57 VDD.t1 sg13_lv_pmos ad=0.38p pd=2.38u as=0.68p ps=4.68u w=2u l=0.13u
X157 VDD.t83 a_917_6931.t4 a_1941_6967.t0 VDD.t9 sg13_lv_pmos ad=0.68p pd=4.68u as=0.38p ps=2.38u w=2u l=0.13u
X158 VSS.t259 VX.t1 a_1369_5853.t0 VSS.t258 sg13_lv_nmos ad=0.34p pd=2.68u as=0.19p ps=1.38u w=1u l=0.13u
X159 VDD.t32 a_2380_10309.t2 a_3009_10831.t0 VDD.t0 sg13_lv_pmos ad=0.68p pd=4.68u as=0.38p ps=2.38u w=2u l=0.13u
X160 a_3009_5853.t0 a_2584_5853.t2 a_2907_5853.t0 VSS.t63 sg13_lv_nmos ad=0.19p pd=1.38u as=0.19p ps=1.38u w=1u l=0.13u
X161 a_3521_10309.t3 a_3317_10309.t2 VDD.t84 VDD.t0 sg13_lv_pmos ad=0.68p pd=4.68u as=0.38p ps=2.38u w=2u l=0.13u
X162 a_3521_9195.t1 MEM.t6 VSS.t49 rppd l=0.5u w=0.5u
X163 a_2805_8081.t0 a_1839_8081.t3 VSS.t234 VSS.t99 sg13_lv_nmos ad=0.19p pd=1.38u as=0.34p ps=2.68u w=1u l=0.13u
X164 VSS.t15 VREF.t3 a_1941_8081.t0 VSS.t14 sg13_lv_nmos ad=0.34p pd=2.68u as=0.19p ps=1.38u w=1u l=0.13u
X165 VSS.t98 a_1692_4709.t2 a_1479_4709.t1 VSS.t97 sg13_lv_nmos ad=0.19p pd=1.38u as=0.34p ps=2.68u w=1u l=0.13u
X166 a_1839_5853.t1 VDD.t66 VDD.t67 VDD.t9 sg13_lv_pmos ad=0.38p pd=2.38u as=0.68p ps=4.68u w=2u l=0.13u
X167 a_1267_10309.t0 VDD.t62 VDD.t63 VDD.t0 sg13_lv_pmos ad=0.38p pd=2.38u as=0.68p ps=4.68u w=2u l=0.13u
X168 a_3521_5853.t5 MEM.t7 VSS.t0 rppd l=0.5u w=0.5u
X169 VSS.t59 VSS.t60 VSS.t52 rppd l=0.5u w=0.5u
X170 a_3521_6967.t1 a_3317_6967.t3 VDD.t77 VDD.t9 sg13_lv_pmos ad=0.38p pd=2.38u as=0.68p ps=4.68u w=2u l=0.13u
X171 VDD.t122 a_3317_9195.t2 a_3521_9195.t2 VDD.t1 sg13_lv_pmos ad=0.38p pd=2.38u as=0.38p ps=2.38u w=2u l=0.13u
X172 VDD.t33 a_2130_4709.t2 SPIKE.t1 VDD.t4 sg13_lv_pmos ad=0.68p pd=4.68u as=0.38p ps=2.38u w=2u l=0.13u
X173 VSS.t216 a_3883_4709.t2 a_3545_4709.t1 VSS.t215 sg13_lv_nmos ad=0.34p pd=2.68u as=0.34p ps=2.68u w=1u l=0.65u
X174 VDD.t86 a_917_8508.t5 a_1369_8603.t0 VDD.t1 sg13_lv_pmos ad=0.68p pd=4.68u as=0.38p ps=2.38u w=2u l=0.13u
X175 VSS.t191 VSS.t192 VSS.t71 rppd l=0.5u w=0.5u
X176 VSS.t135 COMP.t2 a_4221_4709.t1 VSS.t134 sg13_lv_nmos ad=0.34p pd=2.68u as=0.34p ps=2.68u w=1u l=0.65u
X177 VSS.t141 VSS.t142 VSS.t90 rppd l=0.5u w=0.5u
X178 a_3009_8603.t0 a_1267_8081.t5 a_2907_8081.t0 VDD.t1 sg13_lv_pmos ad=0.38p pd=2.38u as=0.38p ps=2.38u w=2u l=0.13u
X179 a_3521_8081.t2 a_3317_8081.t3 VSS.t76 VSS.t75 sg13_lv_nmos ad=0.19p pd=1.38u as=0.34p ps=2.68u w=1u l=0.13u
X180 a_1941_10309.t0 a_1839_5853.t4 a_1839_10309.t0 VSS.t136 sg13_lv_nmos ad=0.19p pd=1.38u as=0.19p ps=1.38u w=1u l=0.13u
X181 VDD.t38 a_2380_9195.t2 a_3009_9195.t0 VDD.t1 sg13_lv_pmos ad=0.68p pd=4.68u as=0.38p ps=2.38u w=2u l=0.13u
X182 a_2584_9195.t0 a_1267_9195.t4 VDD.t23 VDD.t1 sg13_lv_pmos ad=0.68p pd=4.68u as=0.68p ps=4.68u w=2u l=0.13u
X183 a_1839_6967.t0 VSS.t173 VSS.t175 VSS.t174 sg13_lv_nmos ad=0.19p pd=1.38u as=0.34p ps=2.68u w=1u l=0.13u
X184 COMP.t1 a_4828_5366.t3 VDD.t14 VDD.t4 sg13_lv_pmos ad=0.38p pd=2.38u as=0.68p ps=4.68u w=2u l=0.13u
X185 a_2951_11577.t1 a_3837_11577.t1 VSS.t36 rhigh l=4u w=0.5u
X186 a_2380_5853.t1 a_1839_5853.t3 VSS.t188 VSS.t187 sg13_lv_nmos ad=0.34p pd=2.68u as=0.34p ps=2.68u w=1u l=0.13u
X187 VSS.t180 VSS.t181 VSS.t71 rppd l=0.5u w=0.5u
X188 a_1267_5853.t1 VDD.t52 VDD.t53 VDD.t9 sg13_lv_pmos ad=0.38p pd=2.38u as=0.68p ps=4.68u w=2u l=0.13u
X189 VSS.t56 VSS.t57 VSS.t46 rppd l=0.5u w=0.5u
X190 VSS.t37 VSS.t38 VSS.t24 rppd l=0.5u w=0.5u
X191 VDD.t91 VDD.t92 VSS.t89 rhigh l=0.96u w=0.5u
X192 VDD.t27 VDD.t28 VSS.t89 rhigh l=0.96u w=0.5u
X193 VSS.t81 VSS.t82 VSS.t7 rppd l=0.5u w=0.5u
X194 VDD.t116 a_917_6931.t7 a_1941_10831.t0 VDD.t0 sg13_lv_pmos ad=0.68p pd=4.68u as=0.38p ps=2.38u w=2u l=0.13u
X195 VSS.t252 VX.t5 a_1369_9917.t0 VSS.t251 sg13_lv_nmos ad=0.34p pd=2.68u as=0.19p ps=1.38u w=1u l=0.13u
X196 a_3009_9917.t0 a_2584_9195.t3 a_2907_9195.t1 VSS.t10 sg13_lv_nmos ad=0.19p pd=1.38u as=0.19p ps=1.38u w=1u l=0.13u
X197 VDD.t30 a_1692_4709.t2 a_1479_4709.t0 VDD.t4 sg13_lv_pmos ad=0.38p pd=2.38u as=0.68p ps=4.68u w=2u l=0.13u
X198 VSS.t246 VSS.t247 VSS.t24 rppd l=0.5u w=0.5u
X199 VSS.t102 a_2380_10309.t2 a_3009_10309.t0 VSS.t101 sg13_lv_nmos ad=0.34p pd=2.68u as=0.19p ps=1.38u w=1u l=0.13u
X200 VSS.t1 VSS.t2 VSS.t0 rppd l=0.5u w=0.5u
X201 VDD.t97 a_3317_5853.t2 a_3521_5853.t1 VDD.t9 sg13_lv_pmos ad=0.38p pd=2.38u as=0.38p ps=2.38u w=2u l=0.13u
X202 a_3521_10309.t5 a_3317_10309.t2 VSS.t157 VSS.t158 sg13_lv_nmos ad=0.34p pd=2.68u as=0.19p ps=1.38u w=1u l=0.13u
X203 a_1267_6967.t1 VSS.t168 VSS.t169 VSS.t124 sg13_lv_nmos ad=0.19p pd=1.38u as=0.34p ps=2.68u w=1u l=0.13u
X204 VSS.t154 VSS.t155 VSS.t71 rppd l=0.5u w=0.5u
X205 a_1839_6967.t1 VDD.t50 VDD.t51 VDD.t9 sg13_lv_pmos ad=0.38p pd=2.38u as=0.68p ps=4.68u w=2u l=0.13u
X206 a_1941_9195.t0 a_1839_10309.t2 a_1839_9195.t0 VDD.t1 sg13_lv_pmos ad=0.38p pd=2.38u as=0.38p ps=2.38u w=2u l=0.13u
X207 a_2380_8081.t0 a_1839_8081.t4 VDD.t40 VDD.t1 sg13_lv_pmos ad=0.68p pd=4.68u as=0.68p ps=4.68u w=2u l=0.13u
X208 a_4828_5366.t0 MEM.t12 VDD.t41 VDD.t4 sg13_lv_pmos ad=0.38p pd=2.38u as=0.38p ps=2.38u w=2u l=0.13u
X209 VSS.t219 VSS.t220 VSS.t49 rppd l=0.5u w=0.5u
X210 a_1267_10309.t1 a_1003_4745.t9 VSS.t202 VSS.t171 sg13_lv_nmos ad=0.19p pd=1.38u as=0.34p ps=2.68u w=1u l=0.13u
X211 VDD.t87 a_4221_4709.t2 a_3883_4709.t0 VDD.t4 sg13_lv_pmos ad=0.68p pd=4.68u as=0.68p ps=4.68u w=2u l=0.65u
X212 VDD.t29 a_2380_5853.t2 a_3009_6375.t0 VDD.t9 sg13_lv_pmos ad=0.68p pd=4.68u as=0.38p ps=2.38u w=2u l=0.13u
X213 a_1839_8081.t1 a_1003_4745.t6 VSS.t211 VSS.t174 sg13_lv_nmos ad=0.19p pd=1.38u as=0.34p ps=2.68u w=1u l=0.13u
X214 a_2584_5853.t0 a_1267_5853.t3 VDD.t110 VDD.t9 sg13_lv_pmos ad=0.68p pd=4.68u as=0.68p ps=4.68u w=2u l=0.13u
X215 a_3984_11577.t1 a_2951_11577.t0 VSS.t39 rhigh l=4u w=0.5u
X216 VSS.t47 VSS.t48 VSS.t46 rppd l=0.5u w=0.5u
X217 a_2769_4709.t1 COMP.t3 a_2897_5460.t0 VSS.t133 sg13_lv_nmos ad=0.34p pd=2.68u as=0.19p ps=1.38u w=1u l=0.13u
X218 VSS.t151 a_3317_6967.t2 a_3521_6967.t2 VSS.t11 sg13_lv_nmos ad=0.19p pd=1.38u as=0.19p ps=1.38u w=1u l=0.13u
X219 VSS.t223 VSS.t224 VSS.t46 rppd l=0.5u w=0.5u
X220 a_2380_9195.t1 a_1839_9195.t4 VSS.t86 VSS.t85 sg13_lv_nmos ad=0.34p pd=2.68u as=0.34p ps=2.68u w=1u l=0.13u
X221 a_1267_6967.t0 VDD.t58 VDD.t59 VDD.t9 sg13_lv_pmos ad=0.38p pd=2.38u as=0.68p ps=4.68u w=2u l=0.13u
X222 a_885_11577.t1 a_1771_11577.t1 VSS.t4 rhigh l=4u w=0.5u
X223 a_1369_9195.t0 a_1267_10309.t2 a_1267_9195.t1 VDD.t1 sg13_lv_pmos ad=0.38p pd=2.38u as=0.38p ps=2.38u w=2u l=0.13u
X224 VSS.t28 a_2380_6967.t2 a_3009_7689.t0 VSS.t27 sg13_lv_nmos ad=0.34p pd=2.68u as=0.19p ps=1.38u w=1u l=0.13u
X225 a_2907_9195.t0 a_2584_9195.t2 a_2805_9195.t0 VDD.t1 sg13_lv_pmos ad=0.38p pd=2.38u as=0.38p ps=2.38u w=2u l=0.13u
X226 VSS.t148 VSS.t149 VSS.t49 rppd l=0.5u w=0.5u
X227 a_2584_6967.t1 a_1267_6967.t4 VSS.t243 VSS.t115 sg13_lv_nmos ad=0.34p pd=2.68u as=0.34p ps=2.68u w=1u l=0.13u
X228 a_2805_5853.t0 a_1839_5853.t2 VSS.t127 VSS.t126 sg13_lv_nmos ad=0.19p pd=1.38u as=0.34p ps=2.68u w=1u l=0.13u
X229 VSS.t87 VSS.t88 VSS.t7 rppd l=0.5u w=0.5u
X230 a_1267_8081.t1 a_1003_4745.t7 VSS.t125 VSS.t124 sg13_lv_nmos ad=0.19p pd=1.38u as=0.34p ps=2.68u w=1u l=0.13u
X231 VSS.t17 VREF.t0 a_1941_5853.t0 VSS.t16 sg13_lv_nmos ad=0.34p pd=2.68u as=0.19p ps=1.38u w=1u l=0.13u
X232 a_3521_5853.t0 MEM.t1 VSS.t0 rppd l=0.5u w=0.5u
X233 a_1692_4709.t1 COMP.t4 VSS.t98 VSS.t132 sg13_lv_nmos ad=0.19p pd=1.38u as=0.19p ps=1.38u w=1u l=0.13u
X234 VSS.t20 VREF.t5 a_1941_10309.t0 VSS.t19 sg13_lv_nmos ad=0.34p pd=2.68u as=0.19p ps=1.38u w=1u l=0.13u
X235 a_1941_6375.t0 a_1839_6967.t2 a_1839_5853.t1 VDD.t9 sg13_lv_pmos ad=0.38p pd=2.38u as=0.38p ps=2.38u w=2u l=0.13u
X236 VDD.t102 VDD.t103 VSS.t36 rhigh l=4u w=0.5u
X237 VSS.t263 VSS.t264 VSS.t24 rppd l=0.5u w=0.5u
X238 a_917_6931.t0 VREF.t2 VSS.t23 VSS.t22 sg13_lv_nmos ad=0.34p pd=2.68u as=0.34p ps=2.68u w=1u l=0.13u
X239 COMP.t0 a_4828_5366.t3 VSS.t33 VSS.t32 sg13_lv_nmos ad=0.19p pd=1.38u as=0.34p ps=2.68u w=1u l=0.13u
X240 VDD.t78 a_3317_6967.t2 a_3521_6967.t1 VDD.t9 sg13_lv_pmos ad=0.38p pd=2.38u as=0.38p ps=2.38u w=2u l=0.13u
X241 a_3521_6967.t0 MEM.t2 VSS.t7 rppd l=0.5u w=0.5u
X242 a_3521_9195.t4 a_3317_9195.t2 VDD.t122 VDD.t1 sg13_lv_pmos ad=0.68p pd=4.68u as=0.38p ps=2.38u w=2u l=0.13u
X243 VSS.t189 VSS.t190 VSS.t46 rppd l=0.5u w=0.5u
X244 a_3521_10309.t0 MEM.t3 VSS.t49 rppd l=0.5u w=0.5u
X245 VSS.t235 VSS.t236 VSS.t71 rppd l=0.5u w=0.5u
X246 VSS.t184 a_1479_4709.t2 a_1071_4709.t1 VSS.t183 sg13_lv_nmos ad=0.34p pd=2.68u as=0.34p ps=2.68u w=1u l=0.13u
X247 a_3521_5853.t2 a_3317_5853.t3 VSS.t62 VSS.t61 sg13_lv_nmos ad=0.19p pd=1.38u as=0.34p ps=2.68u w=1u l=0.13u
X248 a_3317_9195.t0 a_2907_9195.t2 VDD.t37 VDD.t1 sg13_lv_pmos ad=0.68p pd=4.68u as=0.68p ps=4.68u w=2u l=0.13u
X249 a_2805_8603.t0 a_1839_8081.t3 VDD.t115 VDD.t1 sg13_lv_pmos ad=0.38p pd=2.38u as=0.68p ps=4.68u w=2u l=0.13u
X250 VSS.t12 a_3317_8081.t2 a_3521_8081.t2 VSS.t11 sg13_lv_nmos ad=0.19p pd=1.38u as=0.19p ps=1.38u w=1u l=0.13u
X251 a_2584_6967.t0 a_1267_6967.t4 VDD.t124 VDD.t9 sg13_lv_pmos ad=0.68p pd=4.68u as=0.68p ps=4.68u w=2u l=0.13u
X252 VDD.t10 a_2380_6967.t2 a_3009_6967.t0 VDD.t9 sg13_lv_pmos ad=0.68p pd=4.68u as=0.38p ps=2.38u w=2u l=0.13u
X253 VDD.t36 a_917_6931.t5 a_1941_8603.t0 VDD.t1 sg13_lv_pmos ad=0.68p pd=4.68u as=0.38p ps=2.38u w=2u l=0.13u
X254 VDD.t41 a_4828_5366.t2 COMP.t1 VDD.t4 sg13_lv_pmos ad=0.38p pd=2.38u as=0.38p ps=2.38u w=2u l=0.13u
X255 a_1369_10831.t0 a_1267_5853.t5 a_1267_10309.t0 VDD.t0 sg13_lv_pmos ad=0.38p pd=2.38u as=0.38p ps=2.38u w=2u l=0.13u
X256 a_1941_7689.t0 a_1839_8081.t2 a_1839_6967.t0 VSS.t40 sg13_lv_nmos ad=0.19p pd=1.38u as=0.19p ps=1.38u w=1u l=0.13u
X257 VDD.t20 a_3207_4709.t2 a_2840_5276.t0 VDD.t4 sg13_lv_pmos ad=0.68p pd=4.68u as=0.68p ps=4.68u w=2u l=0.65u
X258 VSS.t249 a_1071_4709.t3 a_1003_4745.t2 VSS.t248 sg13_lv_nmos ad=0.19p pd=1.38u as=0.34p ps=2.68u w=1u l=0.13u
X259 VSS.t195 VSS.t196 VSS.t71 rppd l=0.5u w=0.5u
X260 VSS.t265 a_2380_8081.t2 a_3009_8081.t0 VSS.t27 sg13_lv_nmos ad=0.34p pd=2.68u as=0.19p ps=1.38u w=1u l=0.13u
X261 a_1369_6375.t0 a_1267_6967.t2 a_1267_5853.t1 VDD.t9 sg13_lv_pmos ad=0.38p pd=2.38u as=0.38p ps=2.38u w=2u l=0.13u
X262 a_2584_8081.t1 a_1267_8081.t4 VSS.t116 VSS.t115 sg13_lv_nmos ad=0.34p pd=2.68u as=0.34p ps=2.68u w=1u l=0.13u
X263 a_917_6931.t2 a_917_6931.t1 VDD.t109 VDD.t9 sg13_lv_pmos ad=0.68p pd=4.68u as=0.68p ps=4.68u w=2u l=0.13u
X264 a_2907_5853.t1 a_2584_5853.t3 a_2805_6375.t0 VDD.t9 sg13_lv_pmos ad=0.38p pd=2.38u as=0.38p ps=2.38u w=2u l=0.13u
X265 a_3521_6967.t5 MEM.t10 VSS.t7 rppd l=0.5u w=0.5u
X266 VDD.t21 VDD.t22 VSS.t69 rhigh l=4u w=0.5u
X267 a_3521_10309.t1 MEM.t4 VSS.t49 rppd l=0.5u w=0.5u
X268 a_917_8508.t2 VX.t4 VSS.t255 VSS.t22 sg13_lv_nmos ad=0.34p pd=2.68u as=0.34p ps=2.68u w=1u l=0.13u
X269 a_1820_4745.t0 COMP.t4 VDD.t30 VDD.t4 sg13_lv_pmos ad=0.38p pd=2.38u as=0.38p ps=2.38u w=2u l=0.13u
X270 a_4828_5366.t1 MEM.t12 VSS.t131 VSS.t237 sg13_lv_nmos ad=0.19p pd=1.38u as=0.19p ps=1.38u w=1u l=0.13u
X271 a_1918_11577.t1 a_2804_11753.t1 VSS.t69 rhigh l=4u w=0.5u
X272 VDD.t45 VDD.t46 VSS.t39 rhigh l=4u w=0.5u
X273 a_2805_9917.t0 a_1839_9195.t3 VSS.t45 VSS.t44 sg13_lv_nmos ad=0.19p pd=1.38u as=0.34p ps=2.68u w=1u l=0.13u
X274 a_3521_8081.t0 a_3317_8081.t3 VDD.t24 VDD.t1 sg13_lv_pmos ad=0.38p pd=2.38u as=0.68p ps=4.68u w=2u l=0.13u
X275 a_3521_10309.t2 a_3317_10309.t3 VDD.t101 VDD.t0 sg13_lv_pmos ad=0.38p pd=2.38u as=0.68p ps=4.68u w=2u l=0.13u
X276 VSS.t21 VREF.t4 a_1941_9917.t0 VSS.t19 sg13_lv_nmos ad=0.34p pd=2.68u as=0.19p ps=1.38u w=1u l=0.13u
X277 VSS.t200 VSS.t201 VSS.t52 rppd l=0.5u w=0.5u
X278 VSS.t230 VSS.t231 VSS.t41 rppd l=0.5u w=0.5u
X279 a_2584_10309.t0 a_1267_10309.t4 VDD.t11 VDD.t0 sg13_lv_pmos ad=0.68p pd=4.68u as=0.68p ps=4.68u w=2u l=0.13u
X280 a_3521_5853.t3 a_3317_5853.t2 VDD.t97 VDD.t9 sg13_lv_pmos ad=0.68p pd=4.68u as=0.38p ps=2.38u w=2u l=0.13u
X281 a_1369_7689.t0 a_1267_8081.t2 a_1267_6967.t1 VSS.t3 sg13_lv_nmos ad=0.19p pd=1.38u as=0.19p ps=1.38u w=1u l=0.13u
X282 a_1941_6967.t0 a_1839_8081.t2 a_1839_6967.t1 VDD.t9 sg13_lv_pmos ad=0.38p pd=2.38u as=0.38p ps=2.38u w=2u l=0.13u
X283 a_2769_4709.t0 a_2840_5276.t2 VDD.t15 VDD.t4 sg13_lv_pmos ad=0.38p pd=2.38u as=0.38p ps=2.38u w=2u l=0.13u
X284 VDD.t12 VDD.t13 VSS.t31 rhigh l=0.96u w=0.5u
X285 VDD.t17 VDD.t18 VSS.t31 rhigh l=0.96u w=0.5u
X286 a_2907_6967.t0 a_1267_6967.t5 a_2805_7689.t0 VSS.t68 sg13_lv_nmos ad=0.19p pd=1.38u as=0.19p ps=1.38u w=1u l=0.13u
X287 VDD.t121 MEM.t11 a_4828_5366.t0 VDD.t120 sg13_lv_pmos ad=0.68p pd=4.68u as=0.38p ps=2.38u w=2u l=0.13u
X288 VDD.t93 a_1479_4709.t2 a_1071_4709.t0 VDD.t4 sg13_lv_pmos ad=0.68p pd=4.68u as=0.68p ps=4.68u w=2u l=0.13u
X289 a_3317_5853.t0 a_2907_5853.t2 VDD.t71 VDD.t9 sg13_lv_pmos ad=0.68p pd=4.68u as=0.68p ps=4.68u w=2u l=0.13u
X290 VDD.t2 VDD.t3 VSS.t4 rhigh l=4u w=0.5u
X291 a_2805_10831.t0 a_1839_10309.t3 VDD.t70 VDD.t0 sg13_lv_pmos ad=0.38p pd=2.38u as=0.68p ps=4.68u w=2u l=0.13u
X292 a_1941_8081.t0 a_1839_9195.t2 a_1839_8081.t1 VSS.t40 sg13_lv_nmos ad=0.19p pd=1.38u as=0.19p ps=1.38u w=1u l=0.13u
X293 a_1839_5853.t0 a_1003_4745.t4 VSS.t214 VSS.t213 sg13_lv_nmos ad=0.19p pd=1.38u as=0.34p ps=2.68u w=1u l=0.13u
R0 SPIKE.n2 SPIKE.n0 9.44825
R1 SPIKE.n2 SPIKE.n1 9.00165
R2 SPIKE.n1 SPIKE.t2 5.78405
R3 SPIKE.n0 SPIKE.t0 5.78362
R4 SPIKE.n1 SPIKE.t3 4.44314
R5 SPIKE.n0 SPIKE.t1 4.44314
R6 SPIKE SPIKE.n2 4.3147
R7 RST RST.t0 28.0221
R8 COMP.n1 COMP.t4 26.5921
R9 COMP.n2 COMP.t2 24.0005
R10 COMP.n1 COMP.t3 24.0005
R11 COMP COMP.n3 10.8897
R12 COMP.n3 COMP.n0 9.3679
R13 COMP.n0 COMP.t0 6.42431
R14 COMP.n2 COMP.n1 3.8527
R15 COMP.n0 COMP.t1 3.74891
R16 COMP.n3 COMP.n2 0.274641
R17 VREF.n4 VREF.t2 42.0284
R18 VREF.n3 VREF.t0 36.5878
R19 VREF.n0 VREF.t5 35.0698
R20 VREF.n2 VREF.t1 33.5087
R21 VREF.n1 VREF.t3 33.5087
R22 VREF.n0 VREF.t4 33.5087
R23 VREF.n4 VREF.n3 12.0519
R24 VREF.n1 VREF.n0 3.28639
R25 VREF VREF.n4 1.6197
R26 VREF.n2 VREF.n1 1.56159
R27 VREF.n3 VREF.n2 0.17999
R28 MEM.n6 MEM.t0 26.8055
R29 MEM.n1 MEM.t11 24.3107
R30 MEM.n1 MEM.t12 24.0555
R31 MEM.n3 MEM.t3 15.2221
R32 MEM.n5 MEM.t5 15.2221
R33 MEM.n9 MEM.t9 15.2221
R34 MEM.n11 MEM.t10 15.2221
R35 MEM.n12 MEM.t1 15.2221
R36 MEM.n3 MEM.t4 15.1689
R37 MEM.n5 MEM.t6 15.1689
R38 MEM.n9 MEM.t8 15.1689
R39 MEM.n11 MEM.t2 15.1689
R40 MEM.n12 MEM.t7 15.1689
R41 MEM.n4 MEM.n3 7.78544
R42 MEM.n8 MEM.n5 7.78544
R43 MEM.n10 MEM.n9 7.78544
R44 MEM.n14 MEM.n11 7.78544
R45 MEM.n13 MEM.n12 7.78544
R46 MEM.n2 MEM.n1 4.98455
R47 MEM.n15 MEM.n14 2.2505
R48 MEM.n10 MEM.n0 2.2505
R49 MEM.n8 MEM.n7 2.2505
R50 MEM.n15 MEM.n2 2.2017
R51 MEM.n7 MEM.n6 1.93026
R52 MEM.n14 MEM.n10 0.811975
R53 MEM.n16 MEM.n15 0.806205
R54 MEM.n8 MEM.n4 0.804762
R55 MEM.n10 MEM.n8 0.798271
R56 MEM.n7 MEM.n0 0.798271
R57 MEM.n14 MEM.n13 0.770139
R58 MEM MEM.n16 0.2909
R59 MEM.n6 MEM.n4 0.275903
R60 MEM.n13 MEM.n2 0.20783
R61 MEM.n16 MEM.n0 0.00627049
R62 VX.n4 VX.t4 42.0014
R63 VX.n1 VX.t1 36.8093
R64 VX.n0 VX.t6 35.0905
R65 VX.n0 VX.t5 33.5021
R66 VX.n2 VX.t3 33.5021
R67 VX.n1 VX.t2 33.5021
R68 VX.n5 VX.t0 31.178
R69 VX.n4 VX.n3 10.6997
R70 VX.n3 VX.n0 3.0981
R71 VX.n2 VX.n1 1.5889
R72 VX VX.n5 1.01522
R73 VX.n5 VX.n4 0.36151
R74 VX.n3 VX.n2 0.2161
R75 VDD.n121 VDD.t99 24.9639
R76 VDD.n103 VDD.t107 24.9103
R77 VDD.n104 VDD.t106 24.0174
R78 VDD.n105 VDD.t22 24.0174
R79 VDD.n95 VDD.t21 24.0174
R80 VDD.n86 VDD.t130 24.0174
R81 VDD.n119 VDD.t129 24.0174
R82 VDD.n120 VDD.t100 24.0174
R83 VDD.n138 VDD.n137 17.0005
R84 VDD.n137 VDD.n59 17.0005
R85 VDD.n137 VDD.n58 17.0005
R86 VDD.n137 VDD.n68 17.0005
R87 VDD.n137 VDD.n57 17.0005
R88 VDD.n137 VDD.n55 17.0005
R89 VDD.n137 VDD.n54 17.0005
R90 VDD.n137 VDD.n49 17.0005
R91 VDD.n137 VDD.n136 17.0005
R92 VDD.n156 VDD.n147 17.0005
R93 VDD.n197 VDD.n175 17.0005
R94 VDD.n197 VDD.n41 17.0005
R95 VDD.n202 VDD.n201 17.0005
R96 VDD.n204 VDD.n8 17.0005
R97 VDD.n204 VDD.n32 17.0005
R98 VDD.n204 VDD.n2 17.0005
R99 VDD.n205 VDD.n204 17.0005
R100 VDD.n182 VDD.t50 15.8663
R101 VDD.n176 VDD.t58 15.8663
R102 VDD.n148 VDD.t64 15.8393
R103 VDD.n145 VDD.t56 15.8393
R104 VDD.n60 VDD.t62 15.8385
R105 VDD.n65 VDD.t60 15.8385
R106 VDD.n149 VDD.t48 15.8385
R107 VDD.n146 VDD.t54 15.8385
R108 VDD.n183 VDD.t66 15.8385
R109 VDD.n177 VDD.t52 15.8385
R110 VDD.n140 VDD.t92 15.3813
R111 VDD.n127 VDD.t12 15.3741
R112 VDD.n132 VDD.t13 15.3741
R113 VDD.n45 VDD.t91 15.3741
R114 VDD.n93 VDD.t118 15.0195
R115 VDD.n111 VDD.t117 15.0195
R116 VDD.n114 VDD.t103 15.0195
R117 VDD.n90 VDD.t102 15.0195
R118 VDD.n84 VDD.t46 15.0195
R119 VDD.n124 VDD.t45 15.0195
R120 VDD.n98 VDD.t2 15.0174
R121 VDD.n100 VDD.t3 15.0047
R122 VDD.n129 VDD.t111 15.0005
R123 VDD.n128 VDD.t94 15.0005
R124 VDD.n127 VDD.t17 15.0005
R125 VDD.n134 VDD.t112 15.0005
R126 VDD.n133 VDD.t95 15.0005
R127 VDD.n132 VDD.t18 15.0005
R128 VDD.n47 VDD.t80 15.0005
R129 VDD.n46 VDD.t74 15.0005
R130 VDD.n45 VDD.t27 15.0005
R131 VDD.n142 VDD.t81 15.0005
R132 VDD.n141 VDD.t75 15.0005
R133 VDD.n140 VDD.t28 15.0005
R134 VDD.n174 VDD 10.8617
R135 VDD.n201 VDD.n199 10.5182
R136 VDD.n103 VDD.n102 10.253
R137 VDD.n108 VDD.n106 10.253
R138 VDD.n118 VDD.n117 10.253
R139 VDD.n122 VDD.n121 10.253
R140 VDD.n124 VDD.n123 9.9817
R141 VDD.n101 VDD.n100 9.9223
R142 VDD.n150 VDD.n38 9.83267
R143 VDD.n199 VDD.n198 9.83267
R144 VDD VDD.n174 9.33949
R145 VDD.n173 VDD 9.28042
R146 VDD.n123 VDD.n122 9.0005
R147 VDD.n85 VDD.n84 9.0005
R148 VDD.n91 VDD.n90 9.0005
R149 VDD.n117 VDD.n116 9.0005
R150 VDD.n115 VDD.n114 9.0005
R151 VDD.n112 VDD.n111 9.0005
R152 VDD.n109 VDD.n108 9.0005
R153 VDD.n94 VDD.n93 9.0005
R154 VDD.n99 VDD.n98 9.0005
R155 VDD.n102 VDD.n101 9.0005
R156 VDD.n131 VDD.n130 9.0005
R157 VDD.n144 VDD.n143 9.0005
R158 VDD.n137 VDD.n69 8.49014
R159 VDD.n137 VDD.n56 8.49014
R160 VDD.n137 VDD.n76 8.49014
R161 VDD.n137 VDD.n50 8.49014
R162 VDD.n204 VDD.n10 8.48947
R163 VDD.n204 VDD.n27 8.48947
R164 VDD.n204 VDD.n4 8.48947
R165 VDD.n204 VDD.n31 8.48947
R166 VDD.n137 VDD.n63 5.6485
R167 VDD.n137 VDD.n74 5.6485
R168 VDD.n137 VDD.n78 5.6485
R169 VDD.n137 VDD.n80 5.6485
R170 VDD.n137 VDD.n53 5.6485
R171 VDD.n202 VDD.n37 5.64732
R172 VDD.n202 VDD.n35 5.64732
R173 VDD.n204 VDD.n13 5.64732
R174 VDD.n204 VDD.n9 5.64732
R175 VDD.n204 VDD.n16 5.64732
R176 VDD.n204 VDD.n7 5.64732
R177 VDD.n204 VDD.n20 5.64732
R178 VDD.n204 VDD.n6 5.64732
R179 VDD.n204 VDD.n25 5.64732
R180 VDD.n204 VDD.n5 5.64732
R181 VDD.n204 VDD.n29 5.64732
R182 VDD.n204 VDD.n3 5.64732
R183 VDD.n162 VDD.n147 5.63713
R184 VDD.n160 VDD.n147 5.63713
R185 VDD.n154 VDD.n147 5.63713
R186 VDD.n152 VDD.n147 5.63713
R187 VDD.n197 VDD.n42 5.63713
R188 VDD.n197 VDD.n190 5.63713
R189 VDD.n197 VDD.n196 5.63713
R190 VDD.n197 VDD.n40 5.63713
R191 VDD.n137 VDD.n67 4.22414
R192 VDD.n137 VDD.n51 4.22414
R193 VDD.n204 VDD.n34 4.22248
R194 VDD.n137 VDD.n72 4.22248
R195 VDD.n204 VDD.n23 4.22223
R196 VDD.n168 VDD.n147 4.20824
R197 VDD.n166 VDD.n147 4.20824
R198 VDD.n164 VDD.n147 4.20824
R199 VDD.n197 VDD.n43 4.20824
R200 VDD.n197 VDD.n181 4.20824
R201 VDD.n197 VDD.n185 4.20824
R202 VDD.n197 VDD.n188 4.20824
R203 VDD.n36 VDD.t41 3.4611
R204 VDD.n200 VDD.t121 3.46001
R205 VDD.n0 VDD.t14 3.46001
R206 VDD.n52 VDD.t84 3.4272
R207 VDD.n151 VDD.t6 3.4272
R208 VDD.n39 VDD.t97 3.4272
R209 VDD.n151 VDD.t122 3.42673
R210 VDD.n39 VDD.t78 3.42673
R211 VDD.n22 VDD.t15 3.42673
R212 VDD.n17 VDD.t89 3.42673
R213 VDD.n15 VDD.t30 3.42673
R214 VDD.n11 VDD.t125 3.42673
R215 VDD.n64 VDD.t72 3.42654
R216 VDD.n70 VDD.t116 3.42654
R217 VDD.n71 VDD.t105 3.42654
R218 VDD.n73 VDD.t11 3.42654
R219 VDD.n75 VDD.t70 3.42654
R220 VDD.n77 VDD.t32 3.42654
R221 VDD.n79 VDD.t69 3.42654
R222 VDD.n87 VDD.t101 3.42654
R223 VDD.n153 VDD.t24 3.42654
R224 VDD.n155 VDD.t34 3.42654
R225 VDD.n157 VDD.t128 3.42654
R226 VDD.n159 VDD.t115 3.42654
R227 VDD.n161 VDD.t35 3.42654
R228 VDD.n163 VDD.t40 3.42654
R229 VDD.n165 VDD.t36 3.42654
R230 VDD.n169 VDD.t86 3.42654
R231 VDD.n172 VDD.t88 3.42654
R232 VDD.n195 VDD.t19 3.42654
R233 VDD.n194 VDD.t71 3.42654
R234 VDD.n192 VDD.t29 3.42654
R235 VDD.n191 VDD.t39 3.42654
R236 VDD.n189 VDD.t110 3.42654
R237 VDD.n187 VDD.t96 3.42654
R238 VDD.n186 VDD.t68 3.42654
R239 VDD.n180 VDD.t47 3.42654
R240 VDD.n153 VDD.t104 3.42563
R241 VDD.n155 VDD.t37 3.42563
R242 VDD.n157 VDD.t38 3.42563
R243 VDD.n159 VDD.t16 3.42563
R244 VDD.n161 VDD.t23 3.42563
R245 VDD.n163 VDD.t25 3.42563
R246 VDD.n165 VDD.t8 3.42563
R247 VDD.n169 VDD.t73 3.42563
R248 VDD.n195 VDD.t77 3.42563
R249 VDD.n194 VDD.t82 3.42563
R250 VDD.n192 VDD.t10 3.42563
R251 VDD.n191 VDD.t31 3.42563
R252 VDD.n189 VDD.t124 3.42563
R253 VDD.n187 VDD.t76 3.42563
R254 VDD.n186 VDD.t83 3.42563
R255 VDD.n180 VDD.t26 3.42563
R256 VDD.n44 VDD.t109 3.42563
R257 VDD.n1 VDD.t44 3.42563
R258 VDD.n33 VDD.t87 3.42563
R259 VDD.n30 VDD.t108 3.42563
R260 VDD.n28 VDD.t114 3.42563
R261 VDD.n26 VDD.t20 3.42563
R262 VDD.n24 VDD.t42 3.42563
R263 VDD.n21 VDD.t5 3.42563
R264 VDD.n19 VDD.t33 3.42563
R265 VDD.n14 VDD.t93 3.42563
R266 VDD.n12 VDD.t113 3.42563
R267 VDD.n137 VDD.n62 3.36673
R268 VDD.n204 VDD.n18 3.35838
R269 VDD.n170 VDD.n147 3.34652
R270 VDD.n197 VDD.n179 3.34652
R271 VDD.n137 VDD.n126 2.79285
R272 VDD.n158 VDD.n147 2.76849
R273 VDD.n197 VDD.n193 2.76849
R274 VDD.n60 VDD.t63 2.61969
R275 VDD.n65 VDD.t61 2.61969
R276 VDD.n148 VDD.t65 2.61969
R277 VDD.n149 VDD.t49 2.61969
R278 VDD.n145 VDD.t57 2.61969
R279 VDD.n146 VDD.t55 2.61969
R280 VDD.n182 VDD.t51 2.61969
R281 VDD.n183 VDD.t67 2.61969
R282 VDD.n176 VDD.t59 2.61969
R283 VDD.n177 VDD.t53 2.61969
R284 VDD.n203 VDD.n202 2.42957
R285 VDD.n137 VDD.n81 2.38101
R286 VDD.n130 VDD.n38 1.52358
R287 VDD.n173 VDD.n144 1.52358
R288 VDD.n199 VDD.n38 1.51072
R289 VDD.n174 VDD.n173 1.51072
R290 VDD.n101 VDD.n99 1.0917
R291 VDD.n112 VDD.n109 1.0609
R292 VDD.n104 VDD.n103 1.05865
R293 VDD.n106 VDD.n95 1.03933
R294 VDD.n123 VDD.n85 1.0323
R295 VDD.n121 VDD.n120 1.01143
R296 VDD.n116 VDD.n91 1.0015
R297 VDD.n116 VDD.n115 0.9993
R298 VDD.n118 VDD.n86 0.983524
R299 VDD.n119 VDD.n118 0.979232
R300 VDD.n109 VDD.n94 0.9443
R301 VDD.n106 VDD.n105 0.932012
R302 VDD.n61 VDD.n60 0.808349
R303 VDD.n66 VDD.n65 0.808349
R304 VDD.n167 VDD.n149 0.808349
R305 VDD.n171 VDD.n146 0.808349
R306 VDD.n184 VDD.n183 0.808349
R307 VDD.n178 VDD.n177 0.808349
R308 VDD.n167 VDD.n148 0.807611
R309 VDD.n171 VDD.n145 0.807611
R310 VDD.n184 VDD.n182 0.807611
R311 VDD.n178 VDD.n176 0.807611
R312 VDD.n151 VDD.n150 0.617133
R313 VDD.n198 VDD.n39 0.617133
R314 VDD.n150 VDD.n147 0.613257
R315 VDD.n198 VDD.n197 0.613257
R316 VDD.n130 VDD 0.399885
R317 VDD.n144 VDD 0.399885
R318 VDD.n141 VDD.n140 0.372808
R319 VDD.n128 VDD.n127 0.365783
R320 VDD.n133 VDD.n132 0.365783
R321 VDD.n46 VDD.n45 0.365783
R322 VDD.n172 VDD.n171 0.3305
R323 VDD.n204 VDD.t4 0.309591
R324 VDD.n147 VDD.t1 0.298746
R325 VDD.n142 VDD.n141 0.288192
R326 VDD.n129 VDD.n128 0.282764
R327 VDD.n134 VDD.n133 0.282764
R328 VDD.n47 VDD.n46 0.282764
R329 VDD.n137 VDD.t0 0.274694
R330 VDD.n197 VDD.t9 0.274694
R331 VDD.n91 VDD.n85 0.2711
R332 VDD.n115 VDD.n112 0.2711
R333 VDD.n99 VDD.n94 0.2667
R334 VDD.n120 VDD.n119 0.258061
R335 VDD.n105 VDD.n104 0.255915
R336 VDD.n95 VDD.n86 0.251622
R337 VDD.n159 VDD.n158 0.213242
R338 VDD.n193 VDD.n191 0.213242
R339 VDD.n158 VDD.n157 0.203389
R340 VDD.n193 VDD.n192 0.203389
R341 VDD.n143 VDD.n139 0.184686
R342 VDD.n44 VDD.n43 0.170747
R343 VDD.n83 VDD.n81 0.16994
R344 VDD.n178 VDD.n43 0.161838
R345 VDD.n170 VDD.n169 0.161403
R346 VDD.n180 VDD.n179 0.161403
R347 VDD.n167 VDD.n166 0.158525
R348 VDD.n185 VDD.n184 0.158525
R349 VDD.n166 VDD.n165 0.155727
R350 VDD.n186 VDD.n185 0.155727
R351 VDD.n136 VDD.n131 0.152709
R352 VDD.n126 VDD.n82 0.152513
R353 VDD.n171 VDD.n170 0.15244
R354 VDD.n179 VDD.n178 0.15244
R355 VDD.n169 VDD.n168 0.152413
R356 VDD.n181 VDD.n180 0.152413
R357 VDD.n18 VDD.n17 0.14317
R358 VDD.n152 VDD.n151 0.13753
R359 VDD.n154 VDD.n153 0.13753
R360 VDD.n40 VDD.n39 0.13753
R361 VDD.n196 VDD.n195 0.13753
R362 VDD.n131 VDD.n129 0.136902
R363 VDD.n126 VDD.n125 0.134834
R364 VDD.n82 VDD.n81 0.133864
R365 VDD.n18 VDD 0.126936
R366 VDD.n161 VDD.n160 0.126663
R367 VDD.n163 VDD.n162 0.126663
R368 VDD.n190 VDD.n189 0.126663
R369 VDD.n187 VDD.n42 0.126663
R370 VDD.n165 VDD.n164 0.123895
R371 VDD.n188 VDD.n186 0.123895
R372 VDD.n168 VDD.n167 0.121097
R373 VDD.n184 VDD.n181 0.121097
R374 VDD.n164 VDD.n163 0.118042
R375 VDD.n188 VDD.n187 0.118042
R376 VDD.n143 VDD.n142 0.10804
R377 VDD.n160 VDD.n159 0.100863
R378 VDD.n191 VDD.n190 0.100863
R379 VDD.n62 VDD.n48 0.0984744
R380 VDD.n135 VDD.n134 0.0959717
R381 VDD.n139 VDD.n47 0.0959717
R382 VDD VDD.n172 0.0942037
R383 VDD.n100 VDD.n48 0.0935769
R384 VDD.n30 VDD.n3 0.0932081
R385 VDD.n102 VDD.n96 0.093
R386 VDD.n108 VDD.n107 0.093
R387 VDD.n117 VDD.n88 0.093
R388 VDD.n122 VDD.n82 0.093
R389 VDD.n200 VDD.n35 0.0928724
R390 VDD.n37 VDD.n36 0.0928724
R391 VDD.n29 VDD.n28 0.0918501
R392 VDD.n26 VDD.n5 0.0904921
R393 VDD.n34 VDD 0.0902552
R394 VDD.n62 VDD.n61 0.0895862
R395 VDD.n25 VDD.n24 0.0891341
R396 VDD.n67 VDD.n64 0.0877947
R397 VDD.n16 VDD.n15 0.0874403
R398 VDD.n53 VDD.n52 0.0869176
R399 VDD.n67 VDD.n66 0.0857588
R400 VDD.n23 VDD.n21 0.0845544
R401 VDD.n162 VDD.n161 0.0835485
R402 VDD.n189 VDD.n42 0.0835485
R403 VDD.n89 VDD.n51 0.0832007
R404 VDD.n72 VDD.n71 0.081553
R405 VDD.n21 VDD.n20 0.0813292
R406 VDD.n19 VDD.n7 0.0813292
R407 VDD.n14 VDD.n9 0.0813292
R408 VDD.n13 VDD.n12 0.0813292
R409 VDD.n98 VDD.n97 0.0808846
R410 VDD.n74 VDD.n73 0.0802184
R411 VDD.n93 VDD.n92 0.0787692
R412 VDD.n111 VDD.n110 0.0787692
R413 VDD.n114 VDD.n113 0.0787692
R414 VDD.n90 VDD.n89 0.0787692
R415 VDD.n84 VDD.n83 0.0787692
R416 VDD.n125 VDD.n124 0.0787692
R417 VDD.n23 VDD.n22 0.0756527
R418 VDD.n88 VDD.n80 0.0734874
R419 VDD.n153 VDD.n152 0.0726817
R420 VDD.n155 VDD.n154 0.0726817
R421 VDD.n195 VDD.n40 0.0726817
R422 VDD.n196 VDD.n194 0.0726817
R423 VDD VDD.n25 0.072502
R424 VDD.n72 VDD.n70 0.0721025
R425 VDD.n34 VDD.n33 0.072
R426 VDD.n5 VDD 0.071144
R427 VDD VDD.n29 0.0697859
R428 VDD.n52 VDD.n51 0.0686086
R429 VDD VDD.n3 0.0684279
R430 VDD.n64 VDD.n63 0.0677316
R431 VDD.n156 VDD.n155 0.0677222
R432 VDD.n194 VDD.n41 0.0677222
R433 VDD.n78 VDD.n77 0.0638944
R434 VDD.n75 VDD.n74 0.0638944
R435 VDD.n70 VDD.n69 0.0636466
R436 VDD.n107 VDD.n56 0.0623676
R437 VDD VDD.n205 0.0616111
R438 VDD.n20 VDD.n19 0.0599365
R439 VDD.n17 VDD.n7 0.0599365
R440 VDD.n16 VDD.n14 0.0599365
R441 VDD.n12 VDD.n9 0.0599365
R442 VDD.n13 VDD.n11 0.0599365
R443 VDD.n11 VDD.n10 0.0580057
R444 VDD VDD.n6 0.0551834
R445 VDD.n24 VDD.n6 0.0521316
R446 VDD.n89 VDD.n50 0.0495769
R447 VDD.n96 VDD.n63 0.0488811
R448 VDD.n36 VDD.n35 0.0483933
R449 VDD.n37 VDD.n0 0.0483933
R450 VDD.n31 VDD 0.0478205
R451 VDD.n76 VDD.n75 0.0470187
R452 VDD VDD.n4 0.0464625
R453 VDD.n87 VDD.n53 0.046323
R454 VDD.n80 VDD.n79 0.046323
R455 VDD.n113 VDD.n78 0.046323
R456 VDD.n33 VDD.n32 0.0459938
R457 VDD.n27 VDD 0.0451045
R458 VDD.n2 VDD.n1 0.0446358
R459 VDD.n135 VDD.n49 0.0433488
R460 VDD.n92 VDD.n68 0.0433488
R461 VDD.n79 VDD.n54 0.0427093
R462 VDD.n113 VDD.n55 0.0427093
R463 VDD.n61 VDD.n59 0.0427093
R464 VDD VDD.n10 0.0417094
R465 VDD.n96 VDD.n59 0.0401512
R466 VDD.n157 VDD.n156 0.0392037
R467 VDD.n192 VDD.n41 0.0392037
R468 VDD.n110 VDD.n55 0.0356744
R469 VDD.n71 VDD.n57 0.0356744
R470 VDD.n97 VDD.n68 0.0350349
R471 VDD.n138 VDD.n48 0.0350349
R472 VDD.n22 VDD 0.0344506
R473 VDD.n175 VDD 0.0310556
R474 VDD.n110 VDD.n76 0.0310304
R475 VDD.n73 VDD.n56 0.0310304
R476 VDD.n83 VDD.n50 0.0297513
R477 VDD.n27 VDD.n26 0.0274502
R478 VDD VDD.n2 0.0269815
R479 VDD VDD.n138 0.0267209
R480 VDD.n28 VDD.n4 0.0260922
R481 VDD.n32 VDD 0.0256235
R482 VDD VDD.n8 0.0249444
R483 VDD.n77 VDD.n54 0.0248023
R484 VDD.n66 VDD.n58 0.0248023
R485 VDD.n31 VDD.n30 0.0247341
R486 VDD.n92 VDD.n69 0.0233559
R487 VDD.n139 VDD 0.0222442
R488 VDD VDD.n0 0.0201914
R489 VDD.n125 VDD.n49 0.0190465
R490 VDD.n88 VDD.n87 0.0139302
R491 VDD.n97 VDD.n58 0.00945349
R492 VDD.n15 VDD.n8 0.00661111
R493 VDD.n175 VDD.n44 0.00457407
R494 VDD.n107 VDD.n57 0.00433721
R495 VDD.n205 VDD.n1 0.00253704
R496 VDD.n201 VDD.n200 0.00117901
R497 VDD.n136 VDD.n135 0.00113953
R498 VDD.t4 VDD.n203 0.001
R499 VDD.n203 VDD.t120 0.001
R500 VSS.n278 VSS.n86 114783
R501 VSS.t39 VSS.t36 4639.22
R502 VSS.t36 VSS.t69 4639.22
R503 VSS.t69 VSS.t4 4639.22
R504 VSS.n279 VSS.n278 4531.87
R505 VSS.n280 VSS.n279 4531.87
R506 VSS.t89 VSS.n280 4181.58
R507 VSS.t4 VSS.t89 3309.88
R508 VSS.t31 VSS.t39 3161.68
R509 VSS.n281 VSS.t31 1768.73
R510 VSS.n280 VSS.n88 1696.13
R511 VSS.n278 VSS.t248 1330.58
R512 VSS.n282 VSS.n86 1193.88
R513 VSS.n282 VSS.n281 1193.88
R514 VSS.n279 VSS.n19 1151.93
R515 VSS.n283 VSS.n282 403.959
R516 VSS.n281 VSS.n87 403.959
R517 VSS.t248 VSS.t250 280.993
R518 VSS.t166 VSS.n214 200.773
R519 VSS.n26 VSS.t174 200.773
R520 VSS.t237 VSS.t238 194.162
R521 VSS.t85 VSS.n210 192.486
R522 VSS.n33 VSS.t128 192.486
R523 VSS.n229 VSS.t29 192.386
R524 VSS.t115 VSS.n12 192.386
R525 VSS.t183 VSS.n113 189.142
R526 VSS.n225 VSS.t19 185.083
R527 VSS.t14 VSS.n14 185.083
R528 VSS.t16 VSS.n111 184.573
R529 VSS.t238 VSS.n86 182.742
R530 VSS.n223 VSS.t70 174.034
R531 VSS.t3 VSS.n16 174.034
R532 VSS.t58 VSS.n115 173.554
R533 VSS.n119 VSS.t225 173.554
R534 VSS.n139 VSS.t179 159.78
R535 VSS.n275 VSS.t237 154.189
R536 VSS.n231 VSS.t10 151.935
R537 VSS.t44 VSS.n206 151.935
R538 VSS.t55 VSS.n10 151.935
R539 VSS.n37 VSS.t99 151.935
R540 VSS.t22 VSS.n19 151.935
R541 VSS.t63 VSS.n104 151.516
R542 VSS.n146 VSS.t126 151.516
R543 VSS.n235 VSS.t203 150.95
R544 VSS.t119 VSS.n204 150.95
R545 VSS.t75 VSS.n8 150.95
R546 VSS.n41 VSS.t111 150.95
R547 VSS.t61 VSS.n100 150.572
R548 VSS.n127 VSS.t97 148.761
R549 VSS.t156 VSS.n201 146.41
R550 VSS.n46 VSS.t11 146.41
R551 VSS.n157 VSS.t197 146.006
R552 VSS.t5 VSS.n107 136.798
R553 VSS.t177 VSS.n132 135.601
R554 VSS.t158 VSS.n201 135.359
R555 VSS.n46 VSS.t13 135.359
R556 VSS.n157 VSS.t199 134.987
R557 VSS.n127 VSS.t132 132.232
R558 VSS.n231 VSS.t101 129.834
R559 VSS.t176 VSS.n206 129.834
R560 VSS.t27 VSS.n10 129.834
R561 VSS.n37 VSS.t68 129.834
R562 VSS.t93 VSS.n104 129.477
R563 VSS.t134 VSS.n91 124.835
R564 VSS.n20 VSS.t124 123.424
R565 VSS.n139 VSS.t107 121.213
R566 VSS.t163 VSS.n95 116.969
R567 VSS.n223 VSS.t251 107.736
R568 VSS.t171 VSS.n88 107.736
R569 VSS.t253 VSS.n16 107.736
R570 VSS.t258 VSS.n115 107.439
R571 VSS.n277 VSS.t109 107.439
R572 VSS.t136 VSS.n224 105.555
R573 VSS.n15 VSS.t40 105.555
R574 VSS.t32 VSS.n89 104.695
R575 VSS.n146 VSS.t260 101.928
R576 VSS.n225 VSS.t136 96.6856
R577 VSS.t40 VSS.n14 96.6856
R578 VSS.t212 VSS.n111 96.4192
R579 VSS.t251 VSS.n214 95.8024
R580 VSS.n26 VSS.t253 95.8024
R581 VSS.n222 VSS.t171 94.5061
R582 VSS.t124 VSS.n17 94.5061
R583 VSS.t66 VSS.t139 88.1548
R584 VSS.n135 VSS.t177 80.5052
R585 VSS.n124 VSS.t258 79.8903
R586 VSS.n116 VSS.t109 79.8903
R587 VSS.t250 VSS.n277 79.8903
R588 VSS.t101 VSS.n204 73.6022
R589 VSS.n41 VSS.t27 73.6022
R590 VSS.n150 VSS.t93 73.4388
R591 VSS.n230 VSS.t176 72.4066
R592 VSS.t68 VSS.n11 72.4066
R593 VSS.t182 VSS.n105 72.2407
R594 VSS.n6 VSS.t71 71.5752
R595 VSS.n239 VSS.t52 71.5752
R596 VSS.t13 VSS.n6 68.1666
R597 VSS.n239 VSS.t158 68.1666
R598 VSS.n235 VSS.t119 68.0773
R599 VSS.t111 VSS.n8 68.0773
R600 VSS.t199 VSS.n98 68.0135
R601 VSS.t139 VSS.n100 67.9292
R602 VSS.t203 VSS.n202 66.8818
R603 VSS.n45 VSS.t75 66.8818
R604 VSS.n154 VSS.t61 66.7311
R605 VSS.n150 VSS.t66 62.4185
R606 VSS.n202 VSS.t156 55.832
R607 VSS.t11 VSS.n45 55.832
R608 VSS.t197 VSS.n154 55.7118
R609 VSS.t41 VSS.n89 55.2035
R610 VSS.t217 VSS.t5 55.0969
R611 VSS.t107 VSS.t187 55.0969
R612 VSS.t97 VSS.n113 54.1541
R613 VSS.n112 VSS.t77 52.957
R614 VSS.t77 VSS.t212 52.3421
R615 VSS.t132 VSS.t213 52.3421
R616 VSS.n20 VSS.t22 51.6035
R617 VSS.n209 VSS.t44 51.5954
R618 VSS.t99 VSS.n34 51.5954
R619 VSS.t10 VSS.n230 50.3072
R620 VSS.n11 VSS.t55 50.3072
R621 VSS.t215 VSS.t90 49.3052
R622 VSS.t179 VSS.n135 41.9377
R623 VSS.n275 VSS.t130 39.9751
R624 VSS.n5 VSS.t7 36.2161
R625 VSS.n191 VSS.t49 36.0299
R626 VSS.n98 VSS.t215 35.2758
R627 VSS.n96 VSS.t163 33.3227
R628 VSS.n283 VSS.t24 33.3017
R629 VSS.t46 VSS.n87 33.3017
R630 VSS.t41 VSS.n181 30.4574
R631 VSS.t70 VSS.n222 28.2077
R632 VSS.n17 VSS.t3 28.2077
R633 VSS.t133 VSS.t63 27.5487
R634 VSS.t260 VSS.t182 27.5487
R635 VSS.t126 VSS.t34 27.5487
R636 VSS.t29 VSS.n209 26.7335
R637 VSS.n34 VSS.t115 26.7335
R638 VSS.n142 VSS.t217 26.6999
R639 VSS.n229 VSS.t85 26.6409
R640 VSS.t128 VSS.n12 26.6409
R641 VSS.t187 VSS.n107 26.6068
R642 VSS.n181 VSS.t32 24.7467
R643 VSS.t34 VSS.n142 23.9451
R644 VSS.t52 VSS.n192 22.6981
R645 VSS.n105 VSS.t133 22.654
R646 VSS.t19 VSS.n210 18.4543
R647 VSS.n33 VSS.t14 18.4543
R648 VSS.n224 VSS.t166 17.158
R649 VSS.t174 VSS.n15 17.158
R650 VSS.n132 VSS.t16 17.1443
R651 VSS.t213 VSS.n112 17.1443
R652 VSS.n241 VSS.n240 17.0005
R653 VSS.n265 VSS.n264 17.0005
R654 VSS.n264 VSS.n87 17.0005
R655 VSS.n240 VSS.n88 17.0005
R656 VSS.n240 VSS.n223 17.0005
R657 VSS.n240 VSS.n225 17.0005
R658 VSS.n240 VSS.n206 17.0005
R659 VSS.n240 VSS.n231 17.0005
R660 VSS.n240 VSS.n234 17.0005
R661 VSS.n240 VSS.n201 17.0005
R662 VSS.n285 VSS.n284 17.0005
R663 VSS.n284 VSS.n19 17.0005
R664 VSS.n284 VSS.n16 17.0005
R665 VSS.n284 VSS.n14 17.0005
R666 VSS.n284 VSS.n37 17.0005
R667 VSS.n284 VSS.n10 17.0005
R668 VSS.n284 VSS.n9 17.0005
R669 VSS.n284 VSS.n46 17.0005
R670 VSS.n284 VSS.n85 17.0005
R671 VSS.n284 VSS.n283 17.0005
R672 VSS.n277 VSS.n276 17.0005
R673 VSS.n276 VSS.n116 17.0005
R674 VSS.n276 VSS.n119 17.0005
R675 VSS.n276 VSS.n115 17.0005
R676 VSS.n276 VSS.n124 17.0005
R677 VSS.n276 VSS.n126 17.0005
R678 VSS.n276 VSS.n127 17.0005
R679 VSS.n276 VSS.n111 17.0005
R680 VSS.n276 VSS.n139 17.0005
R681 VSS.n276 VSS.n110 17.0005
R682 VSS.n276 VSS.n141 17.0005
R683 VSS.n276 VSS.n106 17.0005
R684 VSS.n276 VSS.n146 17.0005
R685 VSS.n276 VSS.n104 17.0005
R686 VSS.n276 VSS.n103 17.0005
R687 VSS.n276 VSS.n153 17.0005
R688 VSS.n276 VSS.n156 17.0005
R689 VSS.n276 VSS.n157 17.0005
R690 VSS.n276 VSS.n97 17.0005
R691 VSS.n276 VSS.n180 17.0005
R692 VSS.n276 VSS.n93 17.0005
R693 VSS.n276 VSS.n181 17.0005
R694 VSS.n276 VSS.n89 17.0005
R695 VSS.n276 VSS.n274 17.0005
R696 VSS.n276 VSS.n275 17.0005
R697 VSS.t52 VSS.n191 15.7753
R698 VSS.n215 VSS.t165 15.5174
R699 VSS.n218 VSS.t170 15.5174
R700 VSS.n27 VSS.t173 15.5174
R701 VSS.n21 VSS.t168 15.5174
R702 VSS.n193 VSS.t159 15.3892
R703 VSS.n196 VSS.t59 15.3892
R704 VSS.n49 VSS.t191 15.3892
R705 VSS.n52 VSS.t195 15.3892
R706 VSS.n159 VSS.t145 15.3892
R707 VSS.n185 VSS.t186 15.3864
R708 VSS.n182 VSS.t57 15.3864
R709 VSS.n81 VSS.t247 15.3864
R710 VSS.n78 VSS.t104 15.3864
R711 VSS.n270 VSS.t231 15.3864
R712 VSS.n257 VSS.t149 15.2062
R713 VSS.n260 VSS.t51 15.2062
R714 VSS.n252 VSS.t220 15.2062
R715 VSS.n255 VSS.t114 15.2062
R716 VSS.n247 VSS.t148 15.2062
R717 VSS.n250 VSS.t50 15.2062
R718 VSS.n243 VSS.t219 15.2062
R719 VSS.n246 VSS.t113 15.2062
R720 VSS.n71 VSS.t9 15.2062
R721 VSS.n74 VSS.t82 15.2062
R722 VSS.n66 VSS.t88 15.2062
R723 VSS.n69 VSS.t65 15.2062
R724 VSS.n61 VSS.t8 15.2062
R725 VSS.n64 VSS.t81 15.2062
R726 VSS.n57 VSS.t87 15.2062
R727 VSS.n60 VSS.t64 15.2062
R728 VSS.n173 VSS.t206 15.2062
R729 VSS.n176 VSS.t2 15.2062
R730 VSS.n166 VSS.t205 15.2062
R731 VSS.n169 VSS.t1 15.2062
R732 VSS.t0 VSS.t134 15.1712
R733 VSS.n185 VSS.t162 15.0005
R734 VSS.n186 VSS.t96 15.0005
R735 VSS.n187 VSS.t48 15.0005
R736 VSS.n182 VSS.t190 15.0005
R737 VSS.n183 VSS.t224 15.0005
R738 VSS.n184 VSS.t106 15.0005
R739 VSS.n257 VSS.t185 15.0005
R740 VSS.n258 VSS.t161 15.0005
R741 VSS.n259 VSS.t95 15.0005
R742 VSS.n260 VSS.t47 15.0005
R743 VSS.n252 VSS.t56 15.0005
R744 VSS.n253 VSS.t189 15.0005
R745 VSS.n254 VSS.t223 15.0005
R746 VSS.n255 VSS.t105 15.0005
R747 VSS.n247 VSS.t60 15.0005
R748 VSS.n248 VSS.t209 15.0005
R749 VSS.n249 VSS.t54 15.0005
R750 VSS.n250 VSS.t201 15.0005
R751 VSS.n243 VSS.t160 15.0005
R752 VSS.n245 VSS.t228 15.0005
R753 VSS.n244 VSS.t194 15.0005
R754 VSS.n246 VSS.t222 15.0005
R755 VSS.n195 VSS.t221 15.0005
R756 VSS.n194 VSS.t227 15.0005
R757 VSS.n193 VSS.t193 15.0005
R758 VSS.n196 VSS.t208 15.0005
R759 VSS.n197 VSS.t53 15.0005
R760 VSS.n198 VSS.t200 15.0005
R761 VSS.n81 VSS.t26 15.0005
R762 VSS.n82 VSS.t144 15.0005
R763 VSS.n83 VSS.t262 15.0005
R764 VSS.n78 VSS.t38 15.0005
R765 VSS.n79 VSS.t264 15.0005
R766 VSS.n80 VSS.t245 15.0005
R767 VSS.n71 VSS.t246 15.0005
R768 VSS.n72 VSS.t25 15.0005
R769 VSS.n73 VSS.t143 15.0005
R770 VSS.n74 VSS.t261 15.0005
R771 VSS.n66 VSS.t103 15.0005
R772 VSS.n67 VSS.t37 15.0005
R773 VSS.n68 VSS.t263 15.0005
R774 VSS.n69 VSS.t244 15.0005
R775 VSS.n61 VSS.t196 15.0005
R776 VSS.n62 VSS.t181 15.0005
R777 VSS.n63 VSS.t155 15.0005
R778 VSS.n64 VSS.t123 15.0005
R779 VSS.n57 VSS.t192 15.0005
R780 VSS.n59 VSS.t73 15.0005
R781 VSS.n58 VSS.t236 15.0005
R782 VSS.n60 VSS.t84 15.0005
R783 VSS.n51 VSS.t83 15.0005
R784 VSS.n50 VSS.t72 15.0005
R785 VSS.n49 VSS.t235 15.0005
R786 VSS.n52 VSS.t180 15.0005
R787 VSS.n53 VSS.t154 15.0005
R788 VSS.n54 VSS.t122 15.0005
R789 VSS.n270 VSS.t80 15.0005
R790 VSS.n271 VSS.t43 15.0005
R791 VSS.n272 VSS.t118 15.0005
R792 VSS.n173 VSS.t230 15.0005
R793 VSS.n174 VSS.t79 15.0005
R794 VSS.n175 VSS.t42 15.0005
R795 VSS.n176 VSS.t117 15.0005
R796 VSS.n166 VSS.t146 15.0005
R797 VSS.n168 VSS.t142 15.0005
R798 VSS.n167 VSS.t233 15.0005
R799 VSS.n169 VSS.t92 15.0005
R800 VSS.n161 VSS.t91 15.0005
R801 VSS.n160 VSS.t141 15.0005
R802 VSS.n159 VSS.t232 15.0005
R803 VSS.n124 VSS.t183 13.7746
R804 VSS.n119 VSS.t58 13.7746
R805 VSS.t225 VSS.n116 13.7746
R806 VSS.t41 VSS.n91 13.7042
R807 VSS VSS.n286 11.2924
R808 VSS.n268 VSS.n267 10.6772
R809 VSS VSS.n1 9.78459
R810 VSS.n286 VSS 9.49431
R811 VSS.n267 VSS.n85 9.40671
R812 VSS.n266 VSS.n265 9.40671
R813 VSS.t90 VSS.n96 9.30605
R814 VSS.t71 VSS.n5 9.19845
R815 VSS.t24 VSS.n4 8.72064
R816 VSS.n190 VSS.t46 8.72064
R817 VSS.n276 VSS.n118 8.48372
R818 VSS.n276 VSS.n129 8.48372
R819 VSS.n276 VSS.n131 8.48372
R820 VSS.n276 VSS.n134 8.48372
R821 VSS.n276 VSS.n138 8.48372
R822 VSS.n276 VSS.n108 8.48372
R823 VSS.n276 VSS.n145 8.48372
R824 VSS.n276 VSS.n101 8.48372
R825 VSS.n276 VSS.n172 8.48372
R826 VSS.n276 VSS.n90 8.48372
R827 VSS.t7 VSS.n4 7.53728
R828 VSS.t49 VSS.n190 7.53728
R829 VSS.n147 VSS.t35 6.05148
R830 VSS.n152 VSS.t67 6.05148
R831 VSS.n158 VSS.t229 6.05148
R832 VSS.n164 VSS.t216 6.05148
R833 VSS.n171 VSS.t164 6.05148
R834 VSS.n179 VSS.t135 6.05148
R835 VSS.n237 VSS.t241 6.04804
R836 VSS.n236 VSS.t207 6.04804
R837 VSS.n232 VSS.t120 6.04804
R838 VSS.n233 VSS.t121 6.04804
R839 VSS.n207 VSS.t45 6.04804
R840 VSS.n227 VSS.t74 6.04804
R841 VSS.n226 VSS.t86 6.04804
R842 VSS.n212 VSS.t21 6.04804
R843 VSS.n220 VSS.t252 6.04804
R844 VSS.n47 VSS.t151 6.04804
R845 VSS.n43 VSS.t150 6.04804
R846 VSS.n42 VSS.t153 6.04804
R847 VSS.n39 VSS.t28 6.04804
R848 VSS.n38 VSS.t100 6.04804
R849 VSS.n35 VSS.t243 6.04804
R850 VSS.n31 VSS.t147 6.04804
R851 VSS.n30 VSS.t18 6.04804
R852 VSS.n24 VSS.t254 6.04804
R853 VSS.n2 VSS.t23 6.04804
R854 VSS.n0 VSS.t249 6.04804
R855 VSS.n120 VSS.t226 6.04804
R856 VSS.n121 VSS.t184 6.04804
R857 VSS.n125 VSS.t98 6.04804
R858 VSS.n130 VSS.t78 6.04804
R859 VSS.n136 VSS.t178 6.04804
R860 VSS.n109 VSS.t108 6.04804
R861 VSS.n143 VSS.t6 6.04804
R862 VSS.n92 VSS.t33 6.04804
R863 VSS.n269 VSS.t131 6.04804
R864 VSS.n268 VSS.t239 6.04804
R865 VSS.n237 VSS.t157 6.04761
R866 VSS.n236 VSS.t204 6.04761
R867 VSS.n232 VSS.t137 6.04761
R868 VSS.n233 VSS.t102 6.04761
R869 VSS.n207 VSS.t138 6.04761
R870 VSS.n227 VSS.t30 6.04761
R871 VSS.n226 VSS.t210 6.04761
R872 VSS.n212 VSS.t20 6.04761
R873 VSS.n216 VSS.t240 6.04761
R874 VSS.n220 VSS.t256 6.04761
R875 VSS.n219 VSS.t202 6.04761
R876 VSS.n47 VSS.t12 6.04761
R877 VSS.n43 VSS.t76 6.04761
R878 VSS.n42 VSS.t112 6.04761
R879 VSS.n39 VSS.t265 6.04761
R880 VSS.n38 VSS.t234 6.04761
R881 VSS.n35 VSS.t116 6.04761
R882 VSS.n31 VSS.t129 6.04761
R883 VSS.n30 VSS.t15 6.04761
R884 VSS.n28 VSS.t211 6.04761
R885 VSS.n24 VSS.t257 6.04761
R886 VSS.n22 VSS.t125 6.04761
R887 VSS.n2 VSS.t255 6.04761
R888 VSS.n155 VSS.t198 6.04761
R889 VSS.n151 VSS.t62 6.04761
R890 VSS.n102 VSS.t140 6.04761
R891 VSS.n148 VSS.t94 6.04761
R892 VSS.n144 VSS.t127 6.04761
R893 VSS.n140 VSS.t218 6.04761
R894 VSS.n137 VSS.t188 6.04761
R895 VSS.n133 VSS.t17 6.04761
R896 VSS.n128 VSS.t214 6.04761
R897 VSS.n122 VSS.t259 6.04761
R898 VSS.n117 VSS.t110 6.04761
R899 VSS.n264 VSS.n242 5.63713
R900 VSS.n264 VSS.n189 5.63713
R901 VSS.n240 VSS.n228 5.63713
R902 VSS.n240 VSS.n208 5.63713
R903 VSS.n240 VSS.n203 5.63713
R904 VSS.n240 VSS.n238 5.63713
R905 VSS.n284 VSS.n13 5.63713
R906 VSS.n284 VSS.n36 5.63713
R907 VSS.n284 VSS.n44 5.63713
R908 VSS.n284 VSS.n7 5.63713
R909 VSS.n284 VSS.n3 5.63713
R910 VSS.n276 VSS.n123 5.63713
R911 VSS.n276 VSS.n114 5.63713
R912 VSS.n276 VSS.n99 5.63713
R913 VSS.n276 VSS.n165 5.63713
R914 VSS.n215 VSS.t167 5.56245
R915 VSS.n218 VSS.t172 5.56245
R916 VSS.n27 VSS.t175 5.56245
R917 VSS.n21 VSS.t169 5.56245
R918 VSS.n95 VSS.t0 4.71606
R919 VSS.n240 VSS.n217 4.20824
R920 VSS.n240 VSS.n213 4.20824
R921 VSS.n240 VSS.n211 4.20824
R922 VSS.n284 VSS.n18 4.20824
R923 VSS.n284 VSS.n25 4.20824
R924 VSS.n284 VSS.n29 4.20824
R925 VSS.n284 VSS.n32 4.20824
R926 VSS.n284 VSS.n56 4.20824
R927 VSS.n276 VSS.n163 4.20824
R928 VSS.t130 VSS.t41 3.80761
R929 VSS.n240 VSS.n221 3.34652
R930 VSS.n284 VSS.n23 3.34652
R931 VSS.n284 VSS.n48 3.34652
R932 VSS.n276 VSS.n149 3.34652
R933 VSS.n276 VSS.n94 3.34652
R934 VSS.n240 VSS.n200 3.34624
R935 VSS.n276 VSS.n95 2.81893
R936 VSS.n240 VSS.n205 2.76849
R937 VSS.n284 VSS.n40 2.76849
R938 VSS.n276 VSS.n91 2.08344
R939 VSS.n264 VSS.n263 2.03832
R940 VSS.n284 VSS.n77 2.03832
R941 VSS.n276 VSS.n96 1.94092
R942 VSS.n267 VSS.n266 1.51072
R943 VSS.n286 VSS.n1 1.51072
R944 VSS.n276 VSS.n112 1.30676
R945 VSS.n276 VSS.n132 1.30676
R946 VSS.n276 VSS.n135 1.30676
R947 VSS.n276 VSS.n105 1.30676
R948 VSS.n276 VSS.n154 1.30676
R949 VSS.n240 VSS.n222 1.30371
R950 VSS.n240 VSS.n224 1.30371
R951 VSS.n240 VSS.n230 1.30371
R952 VSS.n240 VSS.n202 1.30371
R953 VSS.n284 VSS.n17 1.30371
R954 VSS.n284 VSS.n15 1.30371
R955 VSS.n284 VSS.n11 1.30371
R956 VSS.n284 VSS.n45 1.30371
R957 VSS.n266 VSS 1.16887
R958 VSS.n1 VSS 1.16887
R959 VSS.n216 VSS.n215 0.486087
R960 VSS.n219 VSS.n218 0.486087
R961 VSS.n28 VSS.n27 0.486087
R962 VSS.n22 VSS.n21 0.486087
R963 VSS.n264 VSS.n191 0.460643
R964 VSS.n249 VSS.n248 0.394667
R965 VSS.n245 VSS.n244 0.394667
R966 VSS.n194 VSS.n193 0.394667
R967 VSS.n197 VSS.n196 0.394667
R968 VSS.n63 VSS.n62 0.394667
R969 VSS.n59 VSS.n58 0.394667
R970 VSS.n50 VSS.n49 0.394667
R971 VSS.n53 VSS.n52 0.394667
R972 VSS.n168 VSS.n167 0.394667
R973 VSS.n160 VSS.n159 0.394667
R974 VSS.n186 VSS.n185 0.391902
R975 VSS.n183 VSS.n182 0.391902
R976 VSS.n259 VSS.n258 0.391902
R977 VSS.n254 VSS.n253 0.391902
R978 VSS.n82 VSS.n81 0.391902
R979 VSS.n79 VSS.n78 0.391902
R980 VSS.n73 VSS.n72 0.391902
R981 VSS.n68 VSS.n67 0.391902
R982 VSS.n271 VSS.n270 0.391902
R983 VSS.n175 VSS.n174 0.391902
R984 VSS.n195 VSS.n194 0.389167
R985 VSS.n198 VSS.n197 0.389167
R986 VSS.n51 VSS.n50 0.389167
R987 VSS.n54 VSS.n53 0.389167
R988 VSS.n161 VSS.n160 0.389167
R989 VSS.n187 VSS.n186 0.386402
R990 VSS.n184 VSS.n183 0.386402
R991 VSS.n83 VSS.n82 0.386402
R992 VSS.n80 VSS.n79 0.386402
R993 VSS.n272 VSS.n271 0.386402
R994 VSS.n199 VSS.n195 0.343333
R995 VSS.n199 VSS.n198 0.343333
R996 VSS.n55 VSS.n51 0.343333
R997 VSS.n55 VSS.n54 0.343333
R998 VSS.n162 VSS.n161 0.343333
R999 VSS.n188 VSS.n187 0.341951
R1000 VSS.n188 VSS.n184 0.341951
R1001 VSS.n84 VSS.n83 0.341951
R1002 VSS.n84 VSS.n80 0.341951
R1003 VSS.n273 VSS.n272 0.341951
R1004 VSS.n263 VSS.n251 0.309139
R1005 VSS.n77 VSS.n65 0.309139
R1006 VSS.n250 VSS.n249 0.304833
R1007 VSS.n248 VSS.n247 0.304833
R1008 VSS.n244 VSS.n243 0.304833
R1009 VSS.n246 VSS.n245 0.304833
R1010 VSS.n64 VSS.n63 0.304833
R1011 VSS.n62 VSS.n61 0.304833
R1012 VSS.n58 VSS.n57 0.304833
R1013 VSS.n60 VSS.n59 0.304833
R1014 VSS.n167 VSS.n166 0.304833
R1015 VSS.n169 VSS.n168 0.304833
R1016 VSS.n258 VSS.n257 0.304646
R1017 VSS.n253 VSS.n252 0.304646
R1018 VSS.n72 VSS.n71 0.304646
R1019 VSS.n67 VSS.n66 0.304646
R1020 VSS.n174 VSS.n173 0.304646
R1021 VSS.n261 VSS.n259 0.303451
R1022 VSS.n256 VSS.n254 0.303451
R1023 VSS.n75 VSS.n73 0.303451
R1024 VSS.n70 VSS.n68 0.303451
R1025 VSS.n177 VSS.n175 0.303451
R1026 VSS.n284 VSS.n5 0.269003
R1027 VSS.n262 VSS.n256 0.259
R1028 VSS.n262 VSS.n261 0.259
R1029 VSS.n251 VSS.n246 0.259
R1030 VSS.n251 VSS.n250 0.259
R1031 VSS.n76 VSS.n70 0.259
R1032 VSS.n76 VSS.n75 0.259
R1033 VSS.n65 VSS.n60 0.259
R1034 VSS.n65 VSS.n64 0.259
R1035 VSS.n178 VSS.n177 0.259
R1036 VSS.n170 VSS.n169 0.259
R1037 VSS.n263 VSS.n262 0.254481
R1038 VSS.n77 VSS.n76 0.254481
R1039 VSS.n207 VSS.n205 0.213242
R1040 VSS.n40 VSS.n38 0.213242
R1041 VSS.n269 VSS.n268 0.208278
R1042 VSS.n233 VSS.n205 0.203389
R1043 VSS.n40 VSS.n39 0.203389
R1044 VSS.n200 VSS.n199 0.202548
R1045 VSS.n55 VSS.n48 0.202144
R1046 VSS.n179 VSS.n94 0.18381
R1047 VSS.n18 VSS.n2 0.170747
R1048 VSS.n149 VSS.n148 0.169551
R1049 VSS.n163 VSS.n162 0.167949
R1050 VSS.n171 VSS.n94 0.162625
R1051 VSS.n22 VSS.n18 0.161838
R1052 VSS.n221 VSS.n220 0.161403
R1053 VSS.n24 VSS.n23 0.161403
R1054 VSS.n216 VSS.n213 0.158525
R1055 VSS.n29 VSS.n28 0.158525
R1056 VSS.n213 VSS.n212 0.155727
R1057 VSS.n30 VSS.n29 0.155727
R1058 VSS.n149 VSS.n147 0.154477
R1059 VSS.n221 VSS.n219 0.15244
R1060 VSS.n23 VSS.n22 0.15244
R1061 VSS.n220 VSS.n217 0.152413
R1062 VSS.n25 VSS.n24 0.152413
R1063 VSS.n48 VSS.n47 0.142254
R1064 VSS.n237 VSS.n200 0.141846
R1065 VSS.n242 VSS.n241 0.139904
R1066 VSS.n238 VSS.n237 0.13753
R1067 VSS.n236 VSS.n203 0.13753
R1068 VSS.n47 VSS.n7 0.13753
R1069 VSS.n44 VSS.n43 0.13753
R1070 VSS.n155 VSS.n99 0.13753
R1071 VSS.n125 VSS.n114 0.136511
R1072 VSS.n227 VSS.n208 0.126663
R1073 VSS.n228 VSS.n226 0.126663
R1074 VSS.n36 VSS.n35 0.126663
R1075 VSS.n31 VSS.n13 0.126663
R1076 VSS.n262 VSS.n189 0.124626
R1077 VSS.n76 VSS.n3 0.124626
R1078 VSS.n212 VSS.n211 0.123895
R1079 VSS.n32 VSS.n30 0.123895
R1080 VSS.n163 VSS.n158 0.123895
R1081 VSS.n217 VSS.n216 0.121097
R1082 VSS.n28 VSS.n25 0.121097
R1083 VSS.n226 VSS.n211 0.118042
R1084 VSS.n32 VSS.n31 0.118042
R1085 VSS.n56 VSS.n55 0.111673
R1086 VSS.n65 VSS.n56 0.106838
R1087 VSS.n172 VSS.n170 0.102781
R1088 VSS.n276 VSS.n113 0.101927
R1089 VSS.n276 VSS.n107 0.101927
R1090 VSS.n276 VSS.n150 0.101927
R1091 VSS.n276 VSS.n100 0.101927
R1092 VSS.n130 VSS.n129 0.101763
R1093 VSS.n264 VSS.n190 0.101566
R1094 VSS.n284 VSS.n4 0.101566
R1095 VSS.n240 VSS.n229 0.101454
R1096 VSS.n240 VSS.n204 0.101454
R1097 VSS.n240 VSS.n235 0.101454
R1098 VSS.n284 VSS.n12 0.101454
R1099 VSS.n284 VSS.n41 0.101454
R1100 VSS.n284 VSS.n8 0.101454
R1101 VSS.n208 VSS.n207 0.100863
R1102 VSS.n38 VSS.n36 0.100863
R1103 VSS.n219 VSS 0.0952222
R1104 VSS.n189 VSS.n188 0.0937337
R1105 VSS.n84 VSS.n3 0.0937337
R1106 VSS.n123 VSS.n122 0.0927152
R1107 VSS.n120 VSS.n118 0.0925963
R1108 VSS.n165 VSS.n164 0.0910151
R1109 VSS.n152 VSS.n101 0.0885222
R1110 VSS.n129 VSS.n128 0.0885222
R1111 VSS.n133 VSS.n131 0.0864852
R1112 VSS.n228 VSS.n227 0.0835485
R1113 VSS.n35 VSS.n13 0.0835485
R1114 VSS.n121 VSS.n114 0.0828669
R1115 VSS.n123 VSS.n120 0.0828669
R1116 VSS.n172 VSS.n171 0.0824111
R1117 VSS.n145 VSS.n143 0.0773185
R1118 VSS.n109 VSS.n108 0.0773185
R1119 VSS.n138 VSS.n136 0.0773185
R1120 VSS.n92 VSS.n90 0.0742629
R1121 VSS.n238 VSS.n236 0.0726817
R1122 VSS.n232 VSS.n203 0.0726817
R1123 VSS.n43 VSS.n7 0.0726817
R1124 VSS.n44 VSS.n42 0.0726817
R1125 VSS.n151 VSS.n99 0.0726817
R1126 VSS.n251 VSS.n242 0.0723448
R1127 VSS.n170 VSS.n165 0.0723448
R1128 VSS.n117 VSS.n0 0.0697593
R1129 VSS.n234 VSS.n232 0.0677222
R1130 VSS.n42 VSS.n9 0.0677222
R1131 VSS.n153 VSS.n151 0.0677222
R1132 VSS.n103 VSS.n102 0.0677222
R1133 VSS.n145 VSS.n144 0.0661148
R1134 VSS.n136 VSS.n134 0.0630592
R1135 VSS.n273 VSS.n90 0.0589852
R1136 VSS.n141 VSS.n140 0.0565185
R1137 VSS.n137 VSS.n110 0.0565185
R1138 VSS.n147 VSS.n106 0.0555
R1139 VSS.n178 VSS.n93 0.0544815
R1140 VSS.n134 VSS.n133 0.0538926
R1141 VSS VSS.n285 0.0514259
R1142 VSS.n158 VSS.n156 0.0514259
R1143 VSS.n164 VSS.n97 0.0493889
R1144 VSS.n140 VSS.n108 0.0488
R1145 VSS.n138 VSS.n137 0.0488
R1146 VSS.n118 VSS.n117 0.0477815
R1147 VSS.n265 VSS.n188 0.0463333
R1148 VSS.n85 VSS.n84 0.0463333
R1149 VSS.n274 VSS.n273 0.0463333
R1150 VSS.n234 VSS.n233 0.0392037
R1151 VSS.n39 VSS.n9 0.0392037
R1152 VSS.n148 VSS.n103 0.0392037
R1153 VSS.n144 VSS.n106 0.0392037
R1154 VSS.n131 VSS.n130 0.0386148
R1155 VSS.n102 VSS.n101 0.0375963
R1156 VSS.n122 VSS.n121 0.0351296
R1157 VSS.n274 VSS.n269 0.0310556
R1158 VSS.n93 VSS.n92 0.0310556
R1159 VSS.n143 VSS.n141 0.028
R1160 VSS.n110 VSS.n109 0.028
R1161 VSS VSS.n0 0.0269815
R1162 VSS.n180 VSS.n179 0.0249444
R1163 VSS.n276 VSS.n98 0.0185172
R1164 VSS.n153 VSS.n152 0.0167963
R1165 VSS.n128 VSS.n126 0.0167963
R1166 VSS.n180 VSS.n178 0.0157778
R1167 VSS.n240 VSS.n239 0.0121287
R1168 VSS.n284 VSS.n6 0.0121287
R1169 VSS.n276 VSS.n142 0.00880137
R1170 VSS.n240 VSS.n209 0.00874649
R1171 VSS.n284 VSS.n34 0.00874649
R1172 VSS.n241 VSS.n199 0.00661111
R1173 VSS.n162 VSS.n97 0.00661111
R1174 VSS.n285 VSS.n2 0.00457407
R1175 VSS.n126 VSS.n125 0.00355556
R1176 VSS.n156 VSS.n155 0.00253704
R1177 VSS.n261 VSS.n260 0.00169565
R1178 VSS.n256 VSS.n255 0.00169565
R1179 VSS.n75 VSS.n74 0.00169565
R1180 VSS.n70 VSS.n69 0.00169565
R1181 VSS.n177 VSS.n176 0.00169565
R1182 VSS.n240 VSS.n214 0.00163568
R1183 VSS.n240 VSS.n210 0.00163568
R1184 VSS.n284 VSS.n20 0.00163568
R1185 VSS.n284 VSS.n26 0.00163568
R1186 VSS.n284 VSS.n33 0.00163568
R1187 VSS.n264 VSS.n192 0.001
R1188 VSS.n240 VSS.n192 0.001
R1189 a_4828_5366.t1 a_4828_5366.n0 6.09331
R1190 a_4828_5366.n0 a_4828_5366.t0 4.07891
R1191 a_4828_5366.n0 a_4828_5366.n1 9.2865
R1192 a_4828_5366.n1 a_4828_5366.t2 24.0005
R1193 a_4828_5366.n1 a_4828_5366.t3 24.3679
R1194 a_4221_4709.t1 a_4221_4709.n0 6.42474
R1195 a_4221_4709.n0 a_4221_4709.t0 3.77918
R1196 a_4221_4709.n0 a_4221_4709.t2 33.2887
R1197 a_3883_4709.t1 a_3883_4709.n0 6.4213
R1198 a_3883_4709.n0 a_3883_4709.t0 3.78262
R1199 a_3883_4709.n0 a_3883_4709.t2 33.2887
R1200 a_3545_4709.t1 a_3545_4709.n0 6.41443
R1201 a_3545_4709.n0 a_3545_4709.t0 3.78949
R1202 a_3545_4709.n0 a_3545_4709.t2 33.2887
R1203 a_3207_4709.t1 a_3207_4709.n0 6.42474
R1204 a_3207_4709.n0 a_3207_4709.t0 3.77918
R1205 a_3207_4709.n0 a_3207_4709.t2 33.2887
R1206 a_2840_5276.t1 a_2840_5276.n0 6.42474
R1207 a_2840_5276.n0 a_2840_5276.t0 3.77918
R1208 a_2840_5276.n0 a_2840_5276.t2 33.6605
R1209 a_2769_4709.t1 a_2769_4709.n0 15.9416
R1210 a_2769_4709.n0 a_2769_4709.t0 12.4567
R1211 a_2769_4709.n0 a_2769_4709.t2 24.2843
R1212 a_2538_4709.t1 a_2538_4709.n0 6.05491
R1213 a_2538_4709.n0 a_2538_4709.t2 15.3253
R1214 a_2538_4709.n0 a_2538_4709.t0 4.07623
R1215 a_2130_4709.t1 a_2130_4709.n0 6.42331
R1216 a_2130_4709.n0 a_2130_4709.t0 3.78262
R1217 a_2130_4709.n0 a_2130_4709.n1 9.22186
R1218 a_2130_4709.n1 a_2130_4709.t3 24.4405
R1219 a_2130_4709.n1 a_2130_4709.t2 24.0005
R1220 a_1692_4709.t1 a_1692_4709.n0 15.4076
R1221 a_1692_4709.n0 a_1692_4709.t0 13.017
R1222 a_1692_4709.n0 a_1692_4709.t2 24.2887
R1223 a_1479_4709.t1 a_1479_4709.n0 6.05835
R1224 a_1479_4709.n0 a_1479_4709.t2 15.3003
R1225 a_1479_4709.n0 a_1479_4709.t0 4.07623
R1226 a_1071_4709.t1 a_1071_4709.n0 6.42675
R1227 a_1071_4709.n0 a_1071_4709.t0 3.77918
R1228 a_1071_4709.n0 a_1071_4709.n1 9.22334
R1229 a_1071_4709.n1 a_1071_4709.t3 24.4433
R1230 a_1071_4709.n1 a_1071_4709.t2 24.0005
R1231 a_3521_5853.t0 a_3521_5853.n0 15.2242
R1232 a_3521_5853.n0 a_3521_5853.t5 15.171
R1233 a_3521_5853.n3 a_3521_5853.n2 9.0005
R1234 a_3521_5853.n3 a_3521_5853.n1 9.4493
R1235 a_3521_5853.n0 a_3521_5853.n3 5.8799
R1236 a_3521_5853.n2 a_3521_5853.t4 6.78224
R1237 a_3521_5853.n2 a_3521_5853.t3 3.44483
R1238 a_3521_5853.n1 a_3521_5853.t2 6.78224
R1239 a_3521_5853.n1 a_3521_5853.t1 3.44603
R1240 a_3317_5853.t1 a_3317_5853.n0 6.45159
R1241 a_3317_5853.n0 a_3317_5853.t0 3.77603
R1242 a_3317_5853.n0 a_3317_5853.n1 9.2249
R1243 a_3317_5853.n1 a_3317_5853.t2 24.4493
R1244 a_3317_5853.n1 a_3317_5853.t3 24.0005
R1245 a_2907_5853.n0 a_2907_5853.t1 3.16034
R1246 a_2907_5853.t0 a_2907_5853.n0 7.09373
R1247 a_2907_5853.n0 a_2907_5853.t2 34.1954
R1248 a_2380_5853.t1 a_2380_5853.n0 8.77469
R1249 a_2380_5853.t1 a_2380_5853.n1 17.0005
R1250 a_2380_5853.n0 a_2380_5853.n1 0.00311905
R1251 a_2380_5853.n1 a_2380_5853.t0 4.46953
R1252 a_2380_5853.n0 a_2380_5853.t2 52.9629
R1253 a_2584_5853.n0 a_2584_5853.t0 4.67434
R1254 a_2584_5853.n0 a_2584_5853.n1 19.4208
R1255 a_2584_5853.t1 a_2584_5853.n0 5.61337
R1256 a_2584_5853.n1 a_2584_5853.t3 33.7441
R1257 a_2584_5853.n1 a_2584_5853.t2 33.0005
R1258 a_3521_6967.t0 a_3521_6967.n0 15.171
R1259 a_3521_6967.n0 a_3521_6967.t5 15.2242
R1260 a_3521_6967.n3 a_3521_6967.n2 9.0005
R1261 a_3521_6967.n3 a_3521_6967.n1 9.4493
R1262 a_3521_6967.n0 a_3521_6967.n3 5.8799
R1263 a_3521_6967.n2 a_3521_6967.t3 3.44574
R1264 a_3521_6967.n2 a_3521_6967.t4 6.78181
R1265 a_3521_6967.n1 a_3521_6967.t1 3.44641
R1266 a_3521_6967.n1 a_3521_6967.t2 6.78224
R1267 a_3317_6967.t1 a_3317_6967.n0 6.45224
R1268 a_3317_6967.n0 a_3317_6967.t0 3.77574
R1269 a_3317_6967.n0 a_3317_6967.n1 9.2249
R1270 a_3317_6967.n1 a_3317_6967.t2 24.4493
R1271 a_3317_6967.n1 a_3317_6967.t3 24.0005
R1272 a_2907_6967.t0 a_2907_6967.n0 7.09338
R1273 a_2907_6967.n0 a_2907_6967.t1 3.16043
R1274 a_2907_6967.n0 a_2907_6967.t2 34.1954
R1275 a_2380_6967.t1 a_2380_6967.n0 17.0005
R1276 a_2380_6967.t1 a_2380_6967.n1 8.77469
R1277 a_2380_6967.n1 a_2380_6967.n0 0.00311905
R1278 a_2380_6967.n0 a_2380_6967.t0 4.46991
R1279 a_2380_6967.n1 a_2380_6967.t2 52.9629
R1280 a_2584_6967.t1 a_2584_6967.n0 5.61337
R1281 a_2584_6967.n0 a_2584_6967.t0 4.67406
R1282 a_2584_6967.n0 a_2584_6967.n1 19.4208
R1283 a_2584_6967.n1 a_2584_6967.t2 33.7441
R1284 a_2584_6967.n1 a_2584_6967.t3 33.0005
R1285 a_1267_6967.t1 a_1267_6967.n0 6.4368
R1286 a_1267_6967.n0 a_1267_6967.n1 0.79866
R1287 a_1267_6967.n1 a_1267_6967.t0 2.98514
R1288 a_1267_6967.n1 a_1267_6967.n3 30.4979
R1289 a_1267_6967.n3 a_1267_6967.n2 9.7287
R1290 a_1267_6967.n3 a_1267_6967.t4 24.2519
R1291 a_1267_6967.n2 a_1267_6967.t5 15.0005
R1292 a_1267_6967.n2 a_1267_6967.t3 33.8246
R1293 a_1267_6967.n0 a_1267_6967.t2 72.0681
R1294 a_1839_6967.t0 a_1839_6967.n0 6.4368
R1295 a_1839_6967.n0 a_1839_6967.t1 3.80909
R1296 a_1839_6967.n0 a_1839_6967.n1 9.17498
R1297 a_1839_6967.n1 a_1839_6967.n2 2.98873
R1298 a_1839_6967.n2 a_1839_6967.t4 24.2519
R1299 a_1839_6967.n2 a_1839_6967.t3 24.9575
R1300 a_1839_6967.n1 a_1839_6967.t2 58.206
R1301 a_3521_8081.n0 a_3521_8081.t5 15.2242
R1302 a_3521_8081.t4 a_3521_8081.n0 15.171
R1303 a_3521_8081.n3 a_3521_8081.n2 9.0005
R1304 a_3521_8081.n3 a_3521_8081.n1 9.4493
R1305 a_3521_8081.n0 a_3521_8081.n3 5.8799
R1306 a_3521_8081.n2 a_3521_8081.t3 6.78224
R1307 a_3521_8081.n2 a_3521_8081.t1 3.44483
R1308 a_3521_8081.n1 a_3521_8081.t2 6.78224
R1309 a_3521_8081.n1 a_3521_8081.t0 3.44603
R1310 a_3317_8081.t1 a_3317_8081.n0 6.45159
R1311 a_3317_8081.n0 a_3317_8081.t0 3.77603
R1312 a_3317_8081.n0 a_3317_8081.n1 9.2249
R1313 a_3317_8081.n1 a_3317_8081.t2 24.4493
R1314 a_3317_8081.n1 a_3317_8081.t3 24.0005
R1315 a_2907_8081.n0 a_2907_8081.t0 3.16034
R1316 a_2907_8081.t1 a_2907_8081.n0 7.09373
R1317 a_2907_8081.n0 a_2907_8081.t2 34.1954
R1318 a_2380_8081.t1 a_2380_8081.n0 8.77469
R1319 a_2380_8081.t1 a_2380_8081.n1 17.0005
R1320 a_2380_8081.n0 a_2380_8081.n1 0.00311905
R1321 a_2380_8081.n1 a_2380_8081.t0 4.46953
R1322 a_2380_8081.n0 a_2380_8081.t2 52.9629
R1323 a_2584_8081.n0 a_2584_8081.t0 4.67434
R1324 a_2584_8081.n0 a_2584_8081.n1 19.4208
R1325 a_2584_8081.t1 a_2584_8081.n0 5.61337
R1326 a_2584_8081.n1 a_2584_8081.t3 33.7441
R1327 a_2584_8081.n1 a_2584_8081.t2 33.0005
R1328 a_1267_8081.t1 a_1267_8081.n0 6.43959
R1329 a_1267_8081.n1 a_1267_8081.t0 2.83841
R1330 a_1267_8081.n0 a_1267_8081.n1 0.946969
R1331 a_1267_8081.n1 a_1267_8081.n3 30.7028
R1332 a_1267_8081.n3 a_1267_8081.n2 9.7287
R1333 a_1267_8081.n3 a_1267_8081.t4 24.2519
R1334 a_1267_8081.n2 a_1267_8081.t3 15.0005
R1335 a_1267_8081.n2 a_1267_8081.t5 33.8246
R1336 a_1267_8081.n0 a_1267_8081.t2 71.2013
R1337 a_1839_8081.t1 a_1839_8081.n0 6.43959
R1338 a_1839_8081.n1 a_1839_8081.t0 3.016
R1339 a_1839_8081.n1 a_1839_8081.n2 10.2341
R1340 a_1839_8081.n0 a_1839_8081.n1 0.749131
R1341 a_1839_8081.n2 a_1839_8081.t4 24.2519
R1342 a_1839_8081.n2 a_1839_8081.t3 24.9575
R1343 a_1839_8081.n0 a_1839_8081.t2 71.1758
R1344 a_3521_9195.n0 a_3521_9195.t1 15.171
R1345 a_3521_9195.t0 a_3521_9195.n0 15.2242
R1346 a_3521_9195.n3 a_3521_9195.n2 9.0005
R1347 a_3521_9195.n3 a_3521_9195.n1 9.4493
R1348 a_3521_9195.n0 a_3521_9195.n3 5.8799
R1349 a_3521_9195.n2 a_3521_9195.t4 3.44574
R1350 a_3521_9195.n2 a_3521_9195.t5 6.78181
R1351 a_3521_9195.n1 a_3521_9195.t2 3.44641
R1352 a_3521_9195.n1 a_3521_9195.t3 6.78224
R1353 a_3317_9195.t1 a_3317_9195.n0 6.45224
R1354 a_3317_9195.n0 a_3317_9195.t0 3.77574
R1355 a_3317_9195.n0 a_3317_9195.n1 9.2249
R1356 a_3317_9195.n1 a_3317_9195.t2 24.4493
R1357 a_3317_9195.n1 a_3317_9195.t3 24.0005
R1358 a_2907_9195.t1 a_2907_9195.n0 7.09338
R1359 a_2907_9195.n0 a_2907_9195.t0 3.16043
R1360 a_2907_9195.n0 a_2907_9195.t2 34.1954
R1361 a_2380_9195.t1 a_2380_9195.n0 17.0005
R1362 a_2380_9195.t1 a_2380_9195.n1 8.77469
R1363 a_2380_9195.n1 a_2380_9195.n0 0.00311905
R1364 a_2380_9195.n0 a_2380_9195.t0 4.46991
R1365 a_2380_9195.n1 a_2380_9195.t2 52.9629
R1366 a_2584_9195.t1 a_2584_9195.n0 5.61337
R1367 a_2584_9195.n0 a_2584_9195.t0 4.67406
R1368 a_2584_9195.n0 a_2584_9195.n1 19.4208
R1369 a_2584_9195.n1 a_2584_9195.t2 33.7441
R1370 a_2584_9195.n1 a_2584_9195.t3 33.0005
R1371 a_1267_9195.t0 a_1267_9195.n0 6.42474
R1372 a_1267_9195.n0 a_1267_9195.t1 3.80391
R1373 a_1267_9195.n0 a_1267_9195.n3 18.741
R1374 a_1267_9195.n3 a_1267_9195.t2 53.1829
R1375 a_1267_9195.n3 a_1267_9195.n2 30.8984
R1376 a_1267_9195.n2 a_1267_9195.n1 9.7287
R1377 a_1267_9195.n2 a_1267_9195.t4 24.2519
R1378 a_1267_9195.n1 a_1267_9195.t5 15.0005
R1379 a_1267_9195.n1 a_1267_9195.t3 33.8246
R1380 a_1839_9195.t1 a_1839_9195.n0 6.45399
R1381 a_1839_9195.n0 a_1839_9195.t0 3.79191
R1382 a_1839_9195.n0 a_1839_9195.n1 9.16857
R1383 a_1839_9195.n1 a_1839_9195.n2 1.26845
R1384 a_1839_9195.n2 a_1839_9195.t4 24.2519
R1385 a_1839_9195.n2 a_1839_9195.t3 24.9575
R1386 a_1839_9195.n1 a_1839_9195.t2 40.1097
R1387 a_1003_4745.t3 a_1003_4745.n0 6.75331
R1388 a_1003_4745.n0 a_1003_4745.t1 3.45328
R1389 a_1003_4745.n2 a_1003_4745.n1 9.0005
R1390 a_1003_4745.n0 a_1003_4745.n2 9.44994
R1391 a_1003_4745.n2 a_1003_4745.n3 30.3926
R1392 a_1003_4745.n3 a_1003_4745.n4 13.9065
R1393 a_1003_4745.n4 a_1003_4745.n5 4.88844
R1394 a_1003_4745.n5 a_1003_4745.n6 20.6341
R1395 a_1003_4745.n6 a_1003_4745.n7 4.89751
R1396 a_1003_4745.n7 a_1003_4745.t8 37.8794
R1397 a_1003_4745.n7 a_1003_4745.t6 33.0005
R1398 a_1003_4745.n6 a_1003_4745.t4 33.0005
R1399 a_1003_4745.n5 a_1003_4745.t5 33.5329
R1400 a_1003_4745.n4 a_1003_4745.t7 33.5373
R1401 a_1003_4745.n3 a_1003_4745.t9 24.5593
R1402 a_1003_4745.n1 a_1003_4745.t0 3.44918
R1403 a_1003_4745.n1 a_1003_4745.t2 6.75775
R1404 a_3521_10309.t0 a_3521_10309.n0 15.2242
R1405 a_3521_10309.n0 a_3521_10309.t1 15.171
R1406 a_3521_10309.n3 a_3521_10309.n2 9.0005
R1407 a_3521_10309.n3 a_3521_10309.n1 9.4493
R1408 a_3521_10309.n0 a_3521_10309.n3 5.8799
R1409 a_3521_10309.n2 a_3521_10309.t5 6.78224
R1410 a_3521_10309.n2 a_3521_10309.t3 3.44483
R1411 a_3521_10309.n1 a_3521_10309.t4 6.78224
R1412 a_3521_10309.n1 a_3521_10309.t2 3.44603
R1413 a_3317_10309.t1 a_3317_10309.n0 6.45159
R1414 a_3317_10309.n0 a_3317_10309.t0 3.77603
R1415 a_3317_10309.n0 a_3317_10309.n1 9.2249
R1416 a_3317_10309.n1 a_3317_10309.t2 24.4493
R1417 a_3317_10309.n1 a_3317_10309.t3 24.0005
R1418 a_2907_10309.n0 a_2907_10309.t0 3.16034
R1419 a_2907_10309.t1 a_2907_10309.n0 7.09373
R1420 a_2907_10309.n0 a_2907_10309.t2 34.1954
R1421 a_2380_10309.t1 a_2380_10309.n0 8.77469
R1422 a_2380_10309.t1 a_2380_10309.n1 17.0005
R1423 a_2380_10309.n0 a_2380_10309.n1 0.00311905
R1424 a_2380_10309.n1 a_2380_10309.t0 4.46953
R1425 a_2380_10309.n0 a_2380_10309.t2 52.9629
R1426 a_2584_10309.n0 a_2584_10309.t0 4.67434
R1427 a_2584_10309.n0 a_2584_10309.n1 19.4208
R1428 a_2584_10309.t1 a_2584_10309.n0 5.61337
R1429 a_2584_10309.n1 a_2584_10309.t3 33.7441
R1430 a_2584_10309.n1 a_2584_10309.t2 33.0005
R1431 a_1267_10309.t1 a_1267_10309.n0 6.10959
R1432 a_1267_10309.n0 a_1267_10309.t0 4.13528
R1433 a_1267_10309.n0 a_1267_10309.n3 18.0005
R1434 a_1267_10309.n3 a_1267_10309.t2 52.9325
R1435 a_1267_10309.n3 a_1267_10309.n2 31.4039
R1436 a_1267_10309.n2 a_1267_10309.n1 9.7287
R1437 a_1267_10309.n2 a_1267_10309.t4 24.2519
R1438 a_1267_10309.n1 a_1267_10309.t3 15.0005
R1439 a_1267_10309.n1 a_1267_10309.t5 33.8246
R1440 a_1839_10309.t0 a_1839_10309.n0 6.10959
R1441 a_1839_10309.n0 a_1839_10309.t1 4.13528
R1442 a_1839_10309.n0 a_1839_10309.n2 18.0005
R1443 a_1839_10309.n2 a_1839_10309.t2 52.9325
R1444 a_1839_10309.n2 a_1839_10309.n1 29.0025
R1445 a_1839_10309.n1 a_1839_10309.t4 24.2519
R1446 a_1839_10309.n1 a_1839_10309.t3 24.9575
R1447 a_917_6931.n0 a_917_6931.t1 15.0005
R1448 a_917_6931.t0 a_917_6931.n0 6.7341
R1449 a_917_6931.n0 a_917_6931.t2 3.46158
R1450 a_917_6931.n0 a_917_6931.n1 38.6053
R1451 a_917_6931.n1 a_917_6931.n3 2.11633
R1452 a_917_6931.n3 a_917_6931.n2 2.14693
R1453 a_917_6931.n1 a_917_6931.t3 35.4418
R1454 a_917_6931.n1 a_917_6931.t4 33.3019
R1455 a_917_6931.n3 a_917_6931.t5 33.3019
R1456 a_917_6931.n2 a_917_6931.t6 33.2887
R1457 a_917_6931.n2 a_917_6931.t7 35.4155
R1458 a_1839_5853.t0 a_1839_5853.n0 6.4499
R1459 a_1839_5853.n1 a_1839_5853.t1 2.90472
R1460 a_1839_5853.n0 a_1839_5853.n1 0.864226
R1461 a_1839_5853.n1 a_1839_5853.n2 10.4287
R1462 a_1839_5853.n2 a_1839_5853.t3 24.2519
R1463 a_1839_5853.n2 a_1839_5853.t2 24.9575
R1464 a_1839_5853.n0 a_1839_5853.t4 80.5918
R1465 a_917_8508.n0 a_917_8508.t0 15.0005
R1466 a_917_8508.t2 a_917_8508.n0 6.73932
R1467 a_917_8508.n0 a_917_8508.t1 3.45814
R1468 a_917_8508.n0 a_917_8508.n1 10.0675
R1469 a_917_8508.n1 a_917_8508.n4 9.3019
R1470 a_917_8508.n4 a_917_8508.n3 2.40639
R1471 a_917_8508.n3 a_917_8508.t3 35.7362
R1472 a_917_8508.n3 a_917_8508.t4 33.3019
R1473 a_917_8508.n4 a_917_8508.n2 2.44159
R1474 a_917_8508.n2 a_917_8508.t7 35.7056
R1475 a_917_8508.n2 a_917_8508.t6 33.3019
R1476 a_917_8508.n1 a_917_8508.t5 24.0005
R1477 a_1267_5853.t0 a_1267_5853.n0 6.4499
R1478 a_1267_5853.n1 a_1267_5853.t1 2.74809
R1479 a_1267_5853.n0 a_1267_5853.n1 1.0385
R1480 a_1267_5853.n1 a_1267_5853.n2 30.9319
R1481 a_1267_5853.n2 a_1267_5853.n3 9.7067
R1482 a_1267_5853.n3 a_1267_5853.t2 15.0005
R1483 a_1267_5853.n3 a_1267_5853.t4 33.8246
R1484 a_1267_5853.n2 a_1267_5853.t3 24.2519
R1485 a_1267_5853.n0 a_1267_5853.t5 62.1316
R1486 a_2951_11577.t0 a_2951_11577.t1 50.9669
R1487 a_885_11577.t0 a_885_11577.t1 50.97
R1488 a_3984_11577.t0 a_3984_11577.t1 30.3728
R1489 a_3837_11577.t0 a_3837_11577.t1 30.3728
R1490 a_2804_11753.t0 a_2804_11753.t1 30.1452
R1491 a_1918_11577.t0 a_1918_11577.t1 30.3728
R1492 a_1771_11577.t0 a_1771_11577.t1 30.3656
C0 a_5078_11753# a_5078_11577# 0.03126f
C1 a_4351_6587# VDD 0.02919f
C2 a_4351_6375# a_4351_6160# 0.02872f
C3 a_2004_11577# a_2004_11441# 0.29305f
C4 a_4351_5948# a_4735_5948# 0.01085f
C5 a_4351_7267# a_4735_7267# 0.01085f
C6 VDD a_971_11753# 0.08589f
C7 a_3967_5948# a_3967_6160# 0.02952f
C8 a_4735_9283# a_4735_9495# 0.02952f
C9 a_4735_9710# a_4735_9495# 0.02872f
C10 a_4735_8388# a_4735_8603# 0.02872f
C11 a_4351_10616# a_4351_10831# 0.02872f
C12 VDD a_3037_11577# 0.09042f
C13 a_3967_9710# a_4351_9710# 0.01085f
C14 a_4351_11043# a_4070_11441# 0.01084f
C15 MEM a_4735_9495# 0.01018f
C16 a_2004_11753# VDD 0.08208f
C17 a_4351_8815# a_4351_8603# 0.02952f
C18 a_3967_10616# a_4351_10616# 0.01085f
C19 a_3967_6587# VDD 0.03605f
C20 a_3967_9922# a_4351_9922# 0.01085f
C21 VDD a_538_11753# 0.03013f
C22 a_3967_9495# a_3967_9283# 0.02952f
C23 a_4735_7267# MEM 0.01009f
C24 MEM a_4351_9495# 0.02673f
C25 a_4351_8815# a_4735_8815# 0.01085f
C26 a_4351_6375# MEM 0.02596f
C27 a_3037_11753# a_3037_11577# 0.13024f
C28 VDD a_538_11441# 0.06326f
C29 MEM a_4735_8603# 0.01018f
C30 a_4735_11043# a_4735_10831# 0.02952f
C31 a_2004_11753# a_2004_11933# 0.12339f
C32 VDD VX 1.09717f
C33 a_4351_7055# a_4735_7055# 0.01085f
C34 a_3967_6375# a_3967_6160# 0.02872f
C35 a_4351_6375# a_4735_6375# 0.01085f
C36 SPIKE RST 0.15213f
C37 a_5078_11753# a_5078_11933# 0.02961f
C38 a_4070_11441# a_4070_11577# 0.29305f
C39 a_4351_9710# a_4351_9495# 0.02872f
C40 COMP RST 0.37376f
C41 VDD a_4070_11441# 0.33809f
C42 a_4351_6160# a_4351_5948# 0.02952f
C43 a_3967_6587# a_4351_6587# 0.01085f
C44 SPIKE VDD 0.71716f
C45 MEM COMP 0.14129f
C46 a_538_11577# VDD 0.03563f
C47 a_4351_8176# a_4735_8176# 0.01085f
C48 a_4351_8388# a_4351_8603# 0.02872f
C49 VREF VX 0.12926f
C50 COMP VDD 0.98967f
C51 VDD a_2004_11577# 0.09027f
C52 a_4351_11043# a_4735_11043# 0.01085f
C53 a_4735_8388# a_4735_8176# 0.02952f
C54 VDD a_5078_11577# 0.03912f
C55 MEM a_4351_8603# 0.02673f
C56 a_5078_11441# a_5078_11577# 0.07033f
C57 a_3967_7694# a_3967_7482# 0.02952f
C58 a_3967_10404# a_4351_10404# 0.01085f
C59 VDD a_3037_11441# 0.37462f
C60 a_4351_6375# a_4351_6587# 0.02952f
C61 a_3967_8603# a_4351_8603# 0.01085f
C62 a_3967_9283# a_4351_9283# 0.01085f
C63 VDD a_3967_10831# 0.011f
C64 VDD a_971_11933# 0.11812f
C65 SPIKE VREF 0.02311f
C66 a_4735_5948# a_4735_6160# 0.02952f
C67 a_3967_9710# a_3967_9922# 0.02952f
C68 a_3967_7694# a_4351_7694# 0.01085f
C69 a_4735_8815# VDD 0.02946f
C70 a_3967_8815# a_4351_8815# 0.01085f
C71 a_4351_7482# a_4735_7482# 0.01085f
C72 a_4351_7267# a_4351_7055# 0.02952f
C73 a_4735_6587# VDD 0.02946f
C74 a_5078_11753# VDD 0.03302f
C75 VX a_971_11753# 0.02483f
C76 a_4070_11753# a_4070_11933# 0.12339f
C77 a_4735_7055# VDD 0.02946f
C78 a_3967_10831# a_3967_11043# 0.02952f
C79 a_4735_9283# a_4351_9283# 0.01085f
C80 VDD a_2004_11441# 0.37606f
C81 a_4735_10616# a_4735_10831# 0.02872f
C82 a_4351_9495# a_4735_9495# 0.01085f
C83 a_3967_7055# a_4351_7055# 0.01085f
C84 a_4735_6587# a_4735_6375# 0.02952f
C85 VDD a_4735_11043# 0.03776f
C86 VDD a_538_11933# 0.03079f
C87 a_4735_7694# a_4735_7482# 0.02952f
C88 a_3967_9710# a_3967_9495# 0.02872f
C89 VDD a_4351_9283# 0.02919f
C90 a_971_11577# a_971_11441# 0.29305f
C91 a_3967_6160# a_4351_6160# 0.01085f
C92 a_4351_7267# a_4351_7482# 0.02872f
C93 MEM a_4735_7482# 0.01f
C94 a_3967_10831# a_4351_10831# 0.01085f
C95 a_3967_8176# a_4351_8176# 0.01085f
C96 a_4351_8815# VDD 0.02919f
C97 a_4351_9922# a_4735_9922# 0.01085f
C98 a_4070_11753# MEM 0.03551f
C99 a_4070_11753# a_4070_11577# 0.13024f
C100 a_4735_9710# a_4735_9922# 0.02952f
C101 a_4070_11753# VDD 0.08633f
C102 a_4351_8176# a_4351_8388# 0.02952f
C103 a_4351_7055# VDD 0.02919f
C104 a_3967_10831# a_3967_10616# 0.02872f
C105 MEM a_4351_6160# 0.02638f
C106 a_4351_10616# a_4351_10404# 0.02952f
C107 a_971_11753# a_971_11933# 0.12339f
C108 a_4351_8388# a_4735_8388# 0.01085f
C109 VDD a_971_11441# 0.38094f
C110 VDD a_5078_11933# 0.03315f
C111 a_2004_11753# a_2004_11577# 0.13024f
C112 a_3037_11577# a_3037_11441# 0.29305f
C113 a_4735_6587# a_4351_6587# 0.01085f
C114 a_3967_6375# a_3967_6587# 0.02952f
C115 VDD a_4351_11043# 0.03358f
C116 a_4735_10404# a_4351_10404# 0.01085f
C117 VX a_538_11441# 0.0108f
C118 a_3967_7267# a_4351_7267# 0.01085f
C119 a_4351_7267# MEM 0.02666f
C120 VDD a_3967_9283# 0.03605f
C121 a_538_11577# a_538_11753# 0.03126f
C122 a_4351_6160# a_4735_6160# 0.01085f
C123 MEM a_4351_7482# 0.02653f
C124 a_3967_8815# VDD 0.03605f
C125 a_3967_9495# a_4351_9495# 0.01085f
C126 a_3967_8815# a_3967_8603# 0.02952f
C127 a_4070_11933# VDD 0.11846f
C128 a_3967_7482# a_4351_7482# 0.01085f
C129 a_3967_6375# a_4351_6375# 0.01085f
C130 a_3967_7267# a_3967_7055# 0.02952f
C131 a_4351_10831# a_4735_10831# 0.01085f
C132 a_3967_7055# VDD 0.03605f
C133 a_538_11577# a_538_11441# 0.07033f
C134 a_4351_11043# a_3967_11043# 0.01085f
C135 a_971_11577# VDD 0.0921f
C136 a_538_11577# VX 0.0101f
C137 VDD a_4735_9283# 0.02946f
C138 RST VDD 0.50078f
C139 a_4351_8388# MEM 0.02645f
C140 a_4351_7694# a_4351_7482# 0.02952f
C141 a_3967_5948# a_4351_5948# 0.01085f
C142 a_4351_8603# a_4735_8603# 0.01085f
C143 MEM VDD 3.06374f
C144 a_3967_7267# a_3967_7482# 0.02872f
C145 MEM a_5078_11441# 0.01001f
C146 VDD a_4070_11577# 0.09241f
C147 a_4351_11043# a_4351_10831# 0.02952f
C148 VDD a_5078_11441# 0.07054f
C149 a_3037_11933# VDD 0.11627f
C150 SPIKE COMP 0.51954f
C151 a_4735_7267# a_4735_7055# 0.02952f
C152 a_4351_9710# a_4351_9922# 0.02952f
C153 a_4351_7694# a_4735_7694# 0.01085f
C154 a_3967_8176# a_3967_8388# 0.02952f
C155 a_4351_9710# a_4735_9710# 0.01085f
C156 a_4735_8815# a_4735_8603# 0.02952f
C157 a_538_11753# a_538_11933# 0.02961f
C158 a_3967_10616# a_3967_10404# 0.02952f
C159 a_4351_10616# a_4735_10616# 0.01085f
C160 a_3967_8388# a_4351_8388# 0.01085f
C161 MEM a_4351_9710# 0.02645f
C162 MEM a_4351_10616# 0.02627f
C163 a_4735_10616# a_4735_10404# 0.02952f
C164 VREF VDD 0.22781f
C165 VDD a_3967_11043# 0.04384f
C166 a_4351_9495# a_4351_9283# 0.02952f
C167 a_3967_8388# a_3967_8603# 0.02872f
C168 a_3037_11753# VDD 0.08238f
C169 a_4735_6375# a_4735_6160# 0.02872f
C170 a_4735_7267# a_4735_7482# 0.02872f
C171 a_3037_11753# a_3037_11933# 0.12339f
C172 a_971_11577# a_971_11753# 0.13024f
C173 a_2004_11933# VDD 0.11603f
C174 MEM a_4351_10831# 0.02682f
C175 SPIKE VSS 1.37121f
C176 RST VSS 3.0955f
C177 COMP VSS 2.00003f
C178 VREF VSS 1.93501f
C179 MEM VSS 6.7852f
C180 VX VSS 2.64614f
C181 VDD VSS 30.39165f
C182 a_4735_5948# VSS 0.23941f $ **FLOATING
C183 a_4351_5948# VSS 0.21737f $ **FLOATING
C184 a_3967_5948# VSS 0.23248f $ **FLOATING
C185 a_4735_6160# VSS 0.19978f $ **FLOATING
C186 a_4351_6160# VSS 0.13383f $ **FLOATING
C187 a_3967_6160# VSS 0.19335f $ **FLOATING
C188 a_4735_6375# VSS 0.19881f $ **FLOATING
C189 a_4351_6375# VSS 0.13338f $ **FLOATING
C190 a_3967_6375# VSS 0.18526f $ **FLOATING
C191 a_4735_6587# VSS 0.19814f $ **FLOATING
C192 a_4351_6587# VSS 0.18434f $ **FLOATING
C193 a_3967_6587# VSS 0.18454f $ **FLOATING
C194 a_4735_7055# VSS 0.19814f $ **FLOATING
C195 a_4351_7055# VSS 0.18434f $ **FLOATING
C196 a_3967_7055# VSS 0.18454f $ **FLOATING
C197 a_4735_7267# VSS 0.19881f $ **FLOATING
C198 a_4351_7267# VSS 0.13338f $ **FLOATING
C199 a_3967_7267# VSS 0.18526f $ **FLOATING
C200 a_4735_7482# VSS 0.19978f $ **FLOATING
C201 a_4351_7482# VSS 0.13383f $ **FLOATING
C202 a_3967_7482# VSS 0.19335f $ **FLOATING
C203 a_4735_7694# VSS 0.23555f $ **FLOATING
C204 a_4351_7694# VSS 0.21265f $ **FLOATING
C205 a_3967_7694# VSS 0.22917f $ **FLOATING
C206 a_4735_8176# VSS 0.23555f $ **FLOATING
C207 a_4351_8176# VSS 0.21265f $ **FLOATING
C208 a_3967_8176# VSS 0.22917f $ **FLOATING
C209 a_4735_8388# VSS 0.19978f $ **FLOATING
C210 a_4351_8388# VSS 0.13383f $ **FLOATING
C211 a_3967_8388# VSS 0.19335f $ **FLOATING
C212 a_4735_8603# VSS 0.19881f $ **FLOATING
C213 a_4351_8603# VSS 0.13338f $ **FLOATING
C214 a_3967_8603# VSS 0.18526f $ **FLOATING
C215 a_4735_8815# VSS 0.19814f $ **FLOATING
C216 a_4351_8815# VSS 0.18434f $ **FLOATING
C217 a_3967_8815# VSS 0.18454f $ **FLOATING
C218 a_4735_9283# VSS 0.19814f $ **FLOATING
C219 a_4351_9283# VSS 0.18434f $ **FLOATING
C220 a_3967_9283# VSS 0.18454f $ **FLOATING
C221 a_4735_9495# VSS 0.19881f $ **FLOATING
C222 a_4351_9495# VSS 0.13338f $ **FLOATING
C223 a_3967_9495# VSS 0.18526f $ **FLOATING
C224 a_4735_9710# VSS 0.19978f $ **FLOATING
C225 a_4351_9710# VSS 0.13383f $ **FLOATING
C226 a_3967_9710# VSS 0.19335f $ **FLOATING
C227 a_4735_9922# VSS 0.23555f $ **FLOATING
C228 a_4351_9922# VSS 0.21265f $ **FLOATING
C229 a_3967_9922# VSS 0.22917f $ **FLOATING
C230 a_4735_10404# VSS 0.23555f $ **FLOATING
C231 a_4351_10404# VSS 0.21265f $ **FLOATING
C232 a_3967_10404# VSS 0.22917f $ **FLOATING
C233 a_4735_10616# VSS 0.19978f $ **FLOATING
C234 a_4351_10616# VSS 0.13383f $ **FLOATING
C235 a_3967_10616# VSS 0.19335f $ **FLOATING
C236 a_4735_10831# VSS 0.19881f $ **FLOATING
C237 a_4351_10831# VSS 0.13338f $ **FLOATING
C238 a_3967_10831# VSS 0.18526f $ **FLOATING
C239 a_4735_11043# VSS 0.1975f $ **FLOATING
C240 a_4351_11043# VSS 0.18183f $ **FLOATING
C241 a_3967_11043# VSS 0.18291f $ **FLOATING
C242 a_5078_11441# VSS 0.09026f $ **FLOATING
C243 a_4070_11441# VSS 0.2769f $ **FLOATING
C244 a_3037_11441# VSS 0.25473f $ **FLOATING
C245 a_2004_11441# VSS 0.25733f $ **FLOATING
C246 a_971_11441# VSS 0.25753f $ **FLOATING
C247 a_538_11441# VSS 0.09315f $ **FLOATING
C248 a_5078_11577# VSS 0.06623f $ **FLOATING
C249 a_4070_11577# VSS 0.27596f $ **FLOATING
C250 a_3037_11577# VSS 0.27596f $ **FLOATING
C251 a_2004_11577# VSS 0.27596f $ **FLOATING
C252 a_971_11577# VSS 0.27596f $ **FLOATING
C253 a_538_11577# VSS 0.06623f $ **FLOATING
C254 a_5078_11753# VSS 0.07454f $ **FLOATING
C255 a_4070_11753# VSS 0.3106f $ **FLOATING
C256 a_3037_11753# VSS 0.3106f $ **FLOATING
C257 a_2004_11753# VSS 0.3106f $ **FLOATING
C258 a_971_11753# VSS 0.3106f $ **FLOATING
C259 a_538_11753# VSS 0.07454f $ **FLOATING
C260 a_5078_11933# VSS 0.10134f $ **FLOATING
C261 a_4070_11933# VSS 0.42223f $ **FLOATING
C262 a_3037_11933# VSS 0.42223f $ **FLOATING
C263 a_2004_11933# VSS 0.42223f $ **FLOATING
C264 a_971_11933# VSS 0.42223f $ **FLOATING
C265 a_538_11933# VSS 0.10134f $ **FLOATING
C266 a_1771_11577.t0 VSS 0.18645f
C267 a_1771_11577.t1 VSS 0.18645f
C268 a_1918_11577.t0 VSS 0.18658f
C269 a_1918_11577.t1 VSS 0.18658f
C270 a_2804_11753.t0 VSS 0.10336f
C271 a_2804_11753.t1 VSS 0.10336f
C272 a_3837_11577.t0 VSS 0.18461f
C273 a_3837_11577.t1 VSS 0.18461f
C274 a_3984_11577.t0 VSS 0.18465f
C275 a_3984_11577.t1 VSS 0.18465f
C276 a_885_11577.t0 VSS 0.96301f
C277 a_885_11577.t1 VSS 0.96314f
C278 a_2951_11577.t0 VSS 0.99229f
C279 a_2951_11577.t1 VSS 0.99191f
C280 a_1267_5853.t0 VSS 0.37038f
C281 a_1267_5853.n0 VSS 3.35619f
C282 a_1267_5853.t5 VSS 2.5f
C283 a_1267_5853.n1 VSS 1.15248f
C284 a_1267_5853.t3 VSS 0.62475f
C285 a_1267_5853.n2 VSS 1.18249f
C286 a_1267_5853.n3 VSS 0.36208f
C287 a_1267_5853.t2 VSS 0.20761f
C288 a_1267_5853.t4 VSS 0.45929f
C289 a_1267_5853.t1 VSS 0.6992f
C290 a_917_8508.t2 VSS 0.28781f
C291 a_917_8508.t0 VSS 0.29613f
C292 a_917_8508.n0 VSS 0.5431f
C293 a_917_8508.t5 VSS 0.29281f
C294 a_917_8508.n1 VSS 0.53821f
C295 a_917_8508.t6 VSS 0.34597f
C296 a_917_8508.n2 VSS 1.55271f
C297 a_917_8508.t7 VSS 0.38549f
C298 a_917_8508.t4 VSS 0.34597f
C299 a_917_8508.n3 VSS 1.55807f
C300 a_917_8508.t3 VSS 0.38712f
C301 a_917_8508.n4 VSS 0.8656f
C302 a_917_8508.t1 VSS 0.56329f
C303 a_1839_5853.t0 VSS 0.37172f
C304 a_1839_5853.n0 VSS 3.00046f
C305 a_1839_5853.t4 VSS 3.2873f
C306 a_1839_5853.n1 VSS 0.36237f
C307 a_1839_5853.t2 VSS 0.60022f
C308 a_1839_5853.t3 VSS 0.62701f
C309 a_1839_5853.n2 VSS 1.1486f
C310 a_1839_5853.t1 VSS 0.71003f
C311 a_917_6931.t0 VSS 0.3057f
C312 a_917_6931.t1 VSS 0.3152f
C313 a_917_6931.n0 VSS 1.03143f
C314 a_917_6931.n1 VSS 2.58006f
C315 a_917_6931.t7 VSS 0.40755f
C316 a_917_6931.t6 VSS 0.36627f
C317 a_917_6931.n2 VSS 1.80493f
C318 a_917_6931.t5 VSS 0.36763f
C319 a_917_6931.n3 VSS 1.17663f
C320 a_917_6931.t4 VSS 0.36763f
C321 a_917_6931.t3 VSS 0.40935f
C322 a_917_6931.t2 VSS 0.5988f
C323 a_1839_10309.t0 VSS 0.24664f
C324 a_1839_10309.n0 VSS 0.44753f
C325 a_1839_10309.t3 VSS 0.41086f
C326 a_1839_10309.t4 VSS 0.4292f
C327 a_1839_10309.n1 VSS 0.61734f
C328 a_1839_10309.t2 VSS 0.61415f
C329 a_1839_10309.n2 VSS 1.17182f
C330 a_1839_10309.t1 VSS 0.55391f
C331 a_1267_10309.t1 VSS 0.2409f
C332 a_1267_10309.n0 VSS 0.43711f
C333 a_1267_10309.n1 VSS 0.2433f
C334 a_1267_10309.t3 VSS 0.1393f
C335 a_1267_10309.t5 VSS 0.30818f
C336 a_1267_10309.t4 VSS 0.4192f
C337 a_1267_10309.n2 VSS 0.84297f
C338 a_1267_10309.t2 VSS 0.59984f
C339 a_1267_10309.n3 VSS 1.55286f
C340 a_1267_10309.t0 VSS 0.54101f
C341 a_2584_10309.t1 VSS 0.24112f
C342 a_2584_10309.n0 VSS 0.57378f
C343 a_2584_10309.t0 VSS 0.6054f
C344 a_2584_10309.t2 VSS 0.2278f
C345 a_2584_10309.n1 VSS 0.71484f
C346 a_2584_10309.t3 VSS 0.33152f
C347 a_2380_10309.t1 VSS 0.23296f
C348 a_2380_10309.n0 VSS 0.68345f
C349 a_2380_10309.t2 VSS 0.6699f
C350 a_2380_10309.t0 VSS 0.56567f
C351 a_2380_10309.n1 VSS 0.30907f
C352 a_2907_10309.t1 VSS 0.25615f
C353 a_2907_10309.t2 VSS 0.51794f
C354 a_2907_10309.n0 VSS 0.69788f
C355 a_2907_10309.t0 VSS 0.46668f
C356 a_3317_10309.t1 VSS 0.12024f
C357 a_3317_10309.n0 VSS 0.21588f
C358 a_3317_10309.t3 VSS 0.22721f
C359 a_3317_10309.n1 VSS 0.15593f
C360 a_3317_10309.t2 VSS 0.41411f
C361 a_3317_10309.t0 VSS 0.25287f
C362 a_1369_10831.t0 VSS 0.48553f
C363 a_1941_10831.t0 VSS 0.48954f
C364 a_2805_10831.t0 VSS 0.49859f
C365 a_3009_10831.t0 VSS 0.48629f
C366 a_3521_10309.t0 VSS 0.01708f
C367 a_3521_10309.t1 VSS 0.01683f
C368 a_3521_10309.n0 VSS 0.14715f
C369 a_3521_10309.t2 VSS 0.23256f
C370 a_3521_10309.t4 VSS 0.11932f
C371 a_3521_10309.n1 VSS 0.19179f
C372 a_3521_10309.t3 VSS 0.2098f
C373 a_3521_10309.t5 VSS 0.10794f
C374 a_3521_10309.n2 VSS 0.19003f
C375 a_3521_10309.n3 VSS 0.20454f
C376 a_1003_4745.t3 VSS 0.32537f
C377 a_1003_4745.n0 VSS 0.52145f
C378 a_1003_4745.t2 VSS 0.29437f
C379 a_1003_4745.t0 VSS 0.57417f
C380 a_1003_4745.n1 VSS 0.5167f
C381 a_1003_4745.n2 VSS 2.51472f
C382 a_1003_4745.t9 VSS 0.21135f
C383 a_1003_4745.n3 VSS 2.8319f
C384 a_1003_4745.t7 VSS 0.28875f
C385 a_1003_4745.n4 VSS 2.51627f
C386 a_1003_4745.t5 VSS 0.29395f
C387 a_1003_4745.n5 VSS 1.59833f
C388 a_1003_4745.t4 VSS 0.25809f
C389 a_1003_4745.n6 VSS 1.44182f
C390 a_1003_4745.t6 VSS 0.24945f
C391 a_1003_4745.n7 VSS 2.6566f
C392 a_1003_4745.t8 VSS 0.37861f
C393 a_1003_4745.t1 VSS 0.63666f
C394 a_1369_10309.t0 VSS 0.13149f
C395 a_1941_10309.t0 VSS 0.13245f
C396 a_2805_10309.t0 VSS 0.14301f
C397 a_3009_10309.t0 VSS 0.16008f
C398 a_1839_9195.t1 VSS 0.27243f
C399 a_1839_9195.n0 VSS 0.43111f
C400 a_1839_9195.n1 VSS 1.20221f
C401 a_1839_9195.t2 VSS 0.66006f
C402 a_1839_9195.t3 VSS 0.43974f
C403 a_1839_9195.t4 VSS 0.45937f
C404 a_1839_9195.n2 VSS 0.63091f
C405 a_1839_9195.t0 VSS 0.57105f
C406 a_1267_9195.t0 VSS 0.27567f
C407 a_1267_9195.n0 VSS 0.51504f
C408 a_1267_9195.n1 VSS 0.26895f
C409 a_1267_9195.t5 VSS 0.15493f
C410 a_1267_9195.t3 VSS 0.34274f
C411 a_1267_9195.t4 VSS 0.46621f
C412 a_1267_9195.n2 VSS 0.9085f
C413 a_1267_9195.n3 VSS 2.23426f
C414 a_1267_9195.t2 VSS 0.69462f
C415 a_1267_9195.t1 VSS 0.5803f
C416 a_2584_9195.t1 VSS 0.24348f
C417 a_2584_9195.n0 VSS 0.57939f
C418 a_2584_9195.t3 VSS 0.23594f
C419 a_2584_9195.n1 VSS 0.73759f
C420 a_2584_9195.t2 VSS 0.33477f
C421 a_2584_9195.t0 VSS 0.61135f
C422 a_2380_9195.t1 VSS 0.23533f
C423 a_2380_9195.n0 VSS 0.31221f
C424 a_2380_9195.n1 VSS 0.6904f
C425 a_2380_9195.t2 VSS 0.67672f
C426 a_2380_9195.t0 VSS 0.57143f
C427 a_2907_9195.t1 VSS 0.25484f
C428 a_2907_9195.t2 VSS 0.51529f
C429 a_2907_9195.n0 VSS 0.69431f
C430 a_2907_9195.t0 VSS 0.4643f
C431 a_3317_9195.t1 VSS 0.11956f
C432 a_3317_9195.n0 VSS 0.21467f
C433 a_3317_9195.t3 VSS 0.22593f
C434 a_3317_9195.n1 VSS 0.15505f
C435 a_3317_9195.t2 VSS 0.41178f
C436 a_3317_9195.t0 VSS 0.25146f
C437 a_1369_9917.t0 VSS 0.13092f
C438 a_1941_9917.t0 VSS 0.13115f
C439 a_2805_9917.t0 VSS 0.143f
C440 a_3009_9917.t0 VSS 0.15996f
C441 a_3521_9195.t0 VSS 0.01682f
C442 a_3521_9195.t1 VSS 0.01657f
C443 a_3521_9195.n0 VSS 0.14488f
C444 a_3521_9195.t3 VSS 0.11747f
C445 a_3521_9195.t2 VSS 0.22898f
C446 a_3521_9195.n1 VSS 0.18882f
C447 a_3521_9195.t5 VSS 0.10627f
C448 a_3521_9195.t4 VSS 0.20657f
C449 a_3521_9195.n2 VSS 0.18708f
C450 a_3521_9195.n3 VSS 0.20138f
C451 a_1369_9195.t0 VSS 0.4958f
C452 a_1941_9195.t0 VSS 0.4971f
C453 a_2805_9195.t0 VSS 0.49527f
C454 a_3009_9195.t0 VSS 0.48464f
C455 a_1839_8081.t1 VSS 0.26367f
C456 a_1839_8081.n0 VSS 0.88527f
C457 a_1839_8081.t2 VSS 0.83059f
C458 a_1839_8081.n1 VSS 0.2583f
C459 a_1839_8081.t3 VSS 0.42618f
C460 a_1839_8081.t4 VSS 0.4452f
C461 a_1839_8081.n2 VSS 0.78474f
C462 a_1839_8081.t0 VSS 0.5095f
C463 a_1267_8081.t1 VSS 0.29006f
C464 a_1267_8081.n0 VSS 0.993f
C465 a_1267_8081.t2 VSS 0.92494f
C466 a_1267_8081.n1 VSS 0.92535f
C467 a_1267_8081.n2 VSS 0.28253f
C468 a_1267_8081.t3 VSS 0.16275f
C469 a_1267_8081.t5 VSS 0.36005f
C470 a_1267_8081.t4 VSS 0.48976f
C471 a_1267_8081.n3 VSS 0.88817f
C472 a_1267_8081.t0 VSS 0.55152f
C473 a_2584_8081.t1 VSS 0.24514f
C474 a_2584_8081.n0 VSS 0.58336f
C475 a_2584_8081.t0 VSS 0.61551f
C476 a_2584_8081.t2 VSS 0.24864f
C477 a_2584_8081.n1 VSS 0.77219f
C478 a_2584_8081.t3 VSS 0.33705f
C479 a_2380_8081.t1 VSS 0.23599f
C480 a_2380_8081.n0 VSS 0.69235f
C481 a_2380_8081.t2 VSS 0.67863f
C482 a_2380_8081.t0 VSS 0.57304f
C483 a_2380_8081.n1 VSS 0.3131f
C484 a_2907_8081.t1 VSS 0.25593f
C485 a_2907_8081.t2 VSS 0.51749f
C486 a_2907_8081.n0 VSS 0.69728f
C487 a_2907_8081.t0 VSS 0.46628f
C488 a_3317_8081.t1 VSS 0.11959f
C489 a_3317_8081.n0 VSS 0.21472f
C490 a_3317_8081.t3 VSS 0.22599f
C491 a_3317_8081.n1 VSS 0.15509f
C492 a_3317_8081.t2 VSS 0.41188f
C493 a_3317_8081.t0 VSS 0.25151f
C494 a_1369_8603.t0 VSS 0.50214f
C495 a_1941_8603.t0 VSS 0.50472f
C496 a_2805_8603.t0 VSS 0.49586f
C497 a_3009_8603.t0 VSS 0.48499f
C498 a_3521_8081.t4 VSS 0.01657f
C499 a_3521_8081.t5 VSS 0.01682f
C500 a_3521_8081.n0 VSS 0.14489f
C501 a_3521_8081.t0 VSS 0.22899f
C502 a_3521_8081.t2 VSS 0.11748f
C503 a_3521_8081.n1 VSS 0.18884f
C504 a_3521_8081.t1 VSS 0.20657f
C505 a_3521_8081.t3 VSS 0.10628f
C506 a_3521_8081.n2 VSS 0.1871f
C507 a_3521_8081.n3 VSS 0.20139f
C508 a_1369_8081.t0 VSS 0.13189f
C509 a_1941_8081.t0 VSS 0.13084f
C510 a_2805_8081.t0 VSS 0.14287f
C511 a_3009_8081.t0 VSS 0.15999f
C512 a_1839_6967.t0 VSS 0.29751f
C513 a_1839_6967.n0 VSS 0.47106f
C514 a_1839_6967.n1 VSS 1.48883f
C515 a_1839_6967.t2 VSS 0.80435f
C516 a_1839_6967.t3 VSS 0.48106f
C517 a_1839_6967.t4 VSS 0.50253f
C518 a_1839_6967.n2 VSS 0.56425f
C519 a_1839_6967.t1 VSS 0.62587f
C520 a_1267_6967.t1 VSS 0.28418f
C521 a_1267_6967.n0 VSS 1.18259f
C522 a_1267_6967.t2 VSS 0.99176f
C523 a_1267_6967.n1 VSS 0.86187f
C524 a_1267_6967.n2 VSS 0.27691f
C525 a_1267_6967.t5 VSS 0.15952f
C526 a_1267_6967.t3 VSS 0.35289f
C527 a_1267_6967.t4 VSS 0.48002f
C528 a_1267_6967.n3 VSS 0.84233f
C529 a_1267_6967.t0 VSS 0.5478f
C530 a_2584_6967.t1 VSS 0.24502f
C531 a_2584_6967.n0 VSS 0.58305f
C532 a_2584_6967.t3 VSS 0.24851f
C533 a_2584_6967.n1 VSS 0.77181f
C534 a_2584_6967.t2 VSS 0.33688f
C535 a_2584_6967.t0 VSS 0.61522f
C536 a_2380_6967.t1 VSS 0.23749f
C537 a_2380_6967.n0 VSS 0.31508f
C538 a_2380_6967.n1 VSS 0.69675f
C539 a_2380_6967.t2 VSS 0.68294f
C540 a_2380_6967.t0 VSS 0.57669f
C541 a_2907_6967.t0 VSS 0.25583f
C542 a_2907_6967.t2 VSS 0.51729f
C543 a_2907_6967.n0 VSS 0.69701f
C544 a_2907_6967.t1 VSS 0.4661f
C545 a_3317_6967.t1 VSS 0.11961f
C546 a_3317_6967.n0 VSS 0.21475f
C547 a_3317_6967.t3 VSS 0.22603f
C548 a_3317_6967.n1 VSS 0.15512f
C549 a_3317_6967.t2 VSS 0.41195f
C550 a_3317_6967.t0 VSS 0.25156f
C551 a_1369_7689.t0 VSS 0.13212f
C552 a_1941_7689.t0 VSS 0.13172f
C553 a_2805_7689.t0 VSS 0.14293f
C554 a_3009_7689.t0 VSS 0.16003f
C555 a_3521_6967.t0 VSS 0.01657f
C556 a_3521_6967.t5 VSS 0.01682f
C557 a_3521_6967.n0 VSS 0.1449f
C558 a_3521_6967.t2 VSS 0.11749f
C559 a_3521_6967.t1 VSS 0.229f
C560 a_3521_6967.n1 VSS 0.18884f
C561 a_3521_6967.t4 VSS 0.10628f
C562 a_3521_6967.t3 VSS 0.20659f
C563 a_3521_6967.n2 VSS 0.1871f
C564 a_3521_6967.n3 VSS 0.2014f
C565 a_1369_6967.t0 VSS 0.4974f
C566 a_1941_6967.t0 VSS 0.49581f
C567 a_2805_6967.t0 VSS 0.4952f
C568 a_3009_6967.t0 VSS 0.48464f
C569 a_2584_5853.t1 VSS 0.24458f
C570 a_2584_5853.n0 VSS 0.58203f
C571 a_2584_5853.t0 VSS 0.61411f
C572 a_2584_5853.t2 VSS 0.24807f
C573 a_2584_5853.n1 VSS 0.77044f
C574 a_2584_5853.t3 VSS 0.33628f
C575 a_2380_5853.t1 VSS 0.23514f
C576 a_2380_5853.n0 VSS 0.68985f
C577 a_2380_5853.t2 VSS 0.67617f
C578 a_2380_5853.t0 VSS 0.57096f
C579 a_2380_5853.n1 VSS 0.31197f
C580 a_2907_5853.t0 VSS 0.25658f
C581 a_2907_5853.t2 VSS 0.5188f
C582 a_2907_5853.n0 VSS 0.69905f
C583 a_2907_5853.t1 VSS 0.46746f
C584 a_3317_5853.t1 VSS 0.11982f
C585 a_3317_5853.n0 VSS 0.21514f
C586 a_3317_5853.t3 VSS 0.22643f
C587 a_3317_5853.n1 VSS 0.15539f
C588 a_3317_5853.t2 VSS 0.41269f
C589 a_3317_5853.t0 VSS 0.252f
C590 a_1369_6375.t0 VSS 0.49947f
C591 a_1941_6375.t0 VSS 0.50828f
C592 a_2805_6375.t0 VSS 0.49635f
C593 a_3009_6375.t0 VSS 0.48528f
C594 a_3521_5853.t0 VSS 0.01697f
C595 a_3521_5853.t5 VSS 0.01672f
C596 a_3521_5853.n0 VSS 0.14622f
C597 a_3521_5853.t1 VSS 0.23109f
C598 a_3521_5853.t2 VSS 0.11856f
C599 a_3521_5853.n1 VSS 0.19057f
C600 a_3521_5853.t3 VSS 0.20847f
C601 a_3521_5853.t4 VSS 0.10725f
C602 a_3521_5853.n2 VSS 0.18882f
C603 a_3521_5853.n3 VSS 0.20324f
C604 a_1369_5853.t0 VSS 0.1361f
C605 a_1941_5853.t0 VSS 0.1276f
C606 a_2805_5853.t0 VSS 0.14195f
C607 a_3009_5853.t0 VSS 0.15937f
C608 a_1071_4709.t1 VSS 0.13219f
C609 a_1071_4709.n0 VSS 0.23647f
C610 a_1071_4709.t2 VSS 0.24905f
C611 a_1071_4709.n1 VSS 0.16181f
C612 a_1071_4709.t3 VSS 0.44603f
C613 a_1071_4709.t0 VSS 0.27888f
C614 a_1479_4709.t1 VSS 0.12484f
C615 a_1479_4709.t0 VSS 0.28319f
C616 a_1479_4709.n0 VSS 0.27332f
C617 a_1479_4709.t2 VSS 0.22825f
C618 a_1692_4709.t1 VSS 0.30284f
C619 a_1692_4709.t2 VSS 0.34145f
C620 a_1692_4709.t0 VSS 0.5493f
C621 a_1692_4709.n0 VSS 0.29532f
C622 a_2130_4709.t1 VSS 0.14311f
C623 a_2130_4709.n0 VSS 0.25603f
C624 a_2130_4709.t2 VSS 0.26974f
C625 a_2130_4709.n1 VSS 0.17679f
C626 a_2130_4709.t3 VSS 0.48331f
C627 a_2130_4709.t0 VSS 0.30217f
C628 a_2538_4709.t1 VSS 0.11619f
C629 a_2538_4709.t0 VSS 0.26365f
C630 a_2538_4709.n0 VSS 0.25867f
C631 a_2538_4709.t2 VSS 0.21661f
C632 a_2769_4709.t1 VSS 0.38533f
C633 a_2769_4709.t2 VSS 0.40984f
C634 a_2769_4709.t0 VSS 0.69565f
C635 a_2769_4709.n0 VSS 0.35855f
C636 a_2840_5276.t1 VSS 0.19253f
C637 a_2840_5276.n0 VSS 0.49198f
C638 a_2840_5276.t2 VSS 0.39291f
C639 a_2840_5276.t0 VSS 0.40634f
C640 a_3207_4709.t1 VSS 0.08533f
C641 a_3207_4709.n0 VSS 0.19701f
C642 a_3207_4709.t2 VSS 0.69418f
C643 a_3207_4709.t0 VSS 0.18009f
C644 a_3545_4709.t1 VSS 0.08622f
C645 a_3545_4709.n0 VSS 0.19917f
C646 a_3545_4709.t2 VSS 0.70224f
C647 a_3545_4709.t0 VSS 0.1824f
C648 a_3883_4709.t1 VSS 0.08636f
C649 a_3883_4709.n0 VSS 0.19941f
C650 a_3883_4709.t2 VSS 0.7028f
C651 a_3883_4709.t0 VSS 0.1824f
C652 a_4221_4709.t1 VSS 0.08672f
C653 a_4221_4709.n0 VSS 0.20022f
C654 a_4221_4709.t2 VSS 0.70551f
C655 a_4221_4709.t0 VSS 0.18303f
C656 a_4828_5366.t1 VSS 0.16541f
C657 a_4828_5366.n0 VSS 0.265f
C658 a_4828_5366.t3 VSS 0.28256f
C659 a_4828_5366.t2 VSS 0.26959f
C660 a_4828_5366.n1 VSS 0.18f
C661 a_4828_5366.t0 VSS 0.36967f
C662 a_2897_5460.t0 VSS 0.15352f
C663 a_1820_4745.t0 VSS 0.4989f
C664 VDD.t14 VSS 0.06685f
C665 VDD.n0 VSS 0.05352f
C666 VDD.t44 VSS 0.06657f
C667 VDD.n1 VSS 0.03942f
C668 VDD.n2 VSS 0.01906f
C669 VDD.n3 VSS 0.03266f
C670 VDD.n4 VSS 0.01006f
C671 VDD.n5 VSS 0.03276f
C672 VDD.n6 VSS 0.01338f
C673 VDD.n7 VSS 0.02579f
C674 VDD.n9 VSS 0.02579f
C675 VDD.n10 VSS 0.02015f
C676 VDD.t125 VSS 0.07382f
C677 VDD.n11 VSS 0.06736f
C678 VDD.t113 VSS 0.06657f
C679 VDD.n12 VSS 0.07593f
C680 VDD.n13 VSS 0.02579f
C681 VDD.t93 VSS 0.06657f
C682 VDD.n14 VSS 0.07593f
C683 VDD.t30 VSS 0.07382f
C684 VDD.n15 VSS 0.0565f
C685 VDD.n16 VSS 0.02778f
C686 VDD.t89 VSS 0.07382f
C687 VDD.n17 VSS 0.0991f
C688 VDD.n18 VSS 0.04792f
C689 VDD.t33 VSS 0.06657f
C690 VDD.n19 VSS 0.07593f
C691 VDD.n20 VSS 0.02579f
C692 VDD.t5 VSS 0.06657f
C693 VDD.n21 VSS 0.0847f
C694 VDD.t15 VSS 0.07382f
C695 VDD.n22 VSS 0.06622f
C696 VDD.n23 VSS 0.0234f
C697 VDD.t42 VSS 0.06657f
C698 VDD.n24 VSS 0.07654f
C699 VDD.n25 VSS 0.0328f
C700 VDD.t20 VSS 0.06657f
C701 VDD.n26 VSS 0.06804f
C702 VDD.n27 VSS 0.01025f
C703 VDD.t114 VSS 0.06657f
C704 VDD.n28 VSS 0.06826f
C705 VDD.n29 VSS 0.03271f
C706 VDD.t108 VSS 0.06657f
C707 VDD.n30 VSS 0.06852f
C708 VDD.n32 VSS 0.01906f
C709 VDD.t87 VSS 0.06657f
C710 VDD.n33 VSS 0.06831f
C711 VDD.n34 VSS 0.02438f
C712 VDD.t120 VSS 0.28206f
C713 VDD.n35 VSS 0.02486f
C714 VDD.t41 VSS 0.07409f
C715 VDD.n36 VSS 0.07731f
C716 VDD.n37 VSS 0.02486f
C717 VDD.n38 VSS 0.73112f
C718 VDD.t78 VSS 0.07382f
C719 VDD.t97 VSS 0.07382f
C720 VDD.n39 VSS 0.18069f
C721 VDD.n40 VSS 0.01668f
C722 VDD.n41 VSS 0.01271f
C723 VDD.n42 VSS 0.0171f
C724 VDD.n43 VSS 0.03075f
C725 VDD.t109 VSS 0.06657f
C726 VDD.n44 VSS 0.05202f
C727 VDD.t91 VSS 0.01985f
C728 VDD.t27 VSS 0.01946f
C729 VDD.n45 VSS 0.03725f
C730 VDD.t74 VSS 0.01946f
C731 VDD.n46 VSS 0.0187f
C732 VDD.t80 VSS 0.01946f
C733 VDD.n47 VSS 0.01091f
C734 VDD.n48 VSS 0.05421f
C735 VDD.n49 VSS 0.01868f
C736 VDD.n50 VSS 0.01541f
C737 VDD.n51 VSS 0.02538f
C738 VDD.t84 VSS 0.07382f
C739 VDD.n52 VSS 0.08868f
C740 VDD.n53 VSS 0.02646f
C741 VDD.n54 VSS 0.02023f
C742 VDD.n55 VSS 0.02354f
C743 VDD.n56 VSS 0.0205f
C744 VDD.n57 VSS 0.01187f
C745 VDD.n58 VSS 0.01012f
C746 VDD.n59 VSS 0.0249f
C747 VDD.t63 VSS 0.06153f
C748 VDD.t62 VSS 0.03608f
C749 VDD.n60 VSS 0.03114f
C750 VDD.n61 VSS 0.06359f
C751 VDD.n62 VSS 0.0308f
C752 VDD.n63 VSS 0.02057f
C753 VDD.t72 VSS 0.06658f
C754 VDD.n64 VSS 0.0877f
C755 VDD.t61 VSS 0.06153f
C756 VDD.t60 VSS 0.03608f
C757 VDD.n65 VSS 0.03114f
C758 VDD.n66 VSS 0.05244f
C759 VDD.n67 VSS 0.03451f
C760 VDD.n68 VSS 0.02354f
C761 VDD.n69 VSS 0.01702f
C762 VDD.t116 VSS 0.06658f
C763 VDD.n70 VSS 0.08126f
C764 VDD.t105 VSS 0.06658f
C765 VDD.n71 VSS 0.07242f
C766 VDD.n72 VSS 0.02385f
C767 VDD.t11 VSS 0.06658f
C768 VDD.n73 VSS 0.06993f
C769 VDD.n74 VSS 0.03165f
C770 VDD.t70 VSS 0.06658f
C771 VDD.n75 VSS 0.06957f
C772 VDD.n76 VSS 0.01507f
C773 VDD.t32 VSS 0.06658f
C774 VDD.n77 VSS 0.05972f
C775 VDD.n78 VSS 0.01784f
C776 VDD.t69 VSS 0.06658f
C777 VDD.n79 VSS 0.06196f
C778 VDD.n80 VSS 0.02156f
C779 VDD.n81 VSS 0.05994f
C780 VDD.n82 VSS 0.11671f
C781 VDD.t45 VSS 0.01946f
C782 VDD.t46 VSS 0.01946f
C783 VDD.n83 VSS 0.0805f
C784 VDD.n85 VSS 0.02516f
C785 VDD.t99 VSS 0.02458f
C786 VDD.t130 VSS 0.02352f
C787 VDD.n86 VSS 0.03189f
C788 VDD.t101 VSS 0.06658f
C789 VDD.n87 VSS 0.0532f
C790 VDD.n88 VSS 0.03342f
C791 VDD.t102 VSS 0.01946f
C792 VDD.n89 VSS 0.05397f
C793 VDD.n91 VSS 0.02452f
C794 VDD.t118 VSS 0.01946f
C795 VDD.n92 VSS 0.02846f
C796 VDD.n94 VSS 0.02326f
C797 VDD.t21 VSS 0.02352f
C798 VDD.n95 VSS 0.0331f
C799 VDD.t107 VSS 0.02448f
C800 VDD.n96 VSS 0.03641f
C801 VDD.t2 VSS 0.01946f
C802 VDD.n97 VSS 0.01547f
C803 VDD.n99 VSS 0.02629f
C804 VDD.t3 VSS 0.01946f
C805 VDD.n100 VSS 0.01004f
C806 VDD.n101 VSS 0.05738f
C807 VDD.n102 VSS 0.0512f
C808 VDD.n103 VSS 0.06998f
C809 VDD.t106 VSS 0.02352f
C810 VDD.n104 VSS 0.03361f
C811 VDD.t22 VSS 0.02352f
C812 VDD.n105 VSS 0.03087f
C813 VDD.n106 VSS 0.04443f
C814 VDD.n107 VSS 0.02415f
C815 VDD.n108 VSS 0.0512f
C816 VDD.n109 VSS 0.03959f
C817 VDD.t117 VSS 0.01946f
C818 VDD.n110 VSS 0.02687f
C819 VDD.n112 VSS 0.02574f
C820 VDD.t103 VSS 0.01946f
C821 VDD.n113 VSS 0.03718f
C822 VDD.n115 VSS 0.02448f
C823 VDD.n116 VSS 0.0395f
C824 VDD.n117 VSS 0.0512f
C825 VDD.n118 VSS 0.04425f
C826 VDD.t129 VSS 0.02352f
C827 VDD.n119 VSS 0.03194f
C828 VDD.t100 VSS 0.02352f
C829 VDD.n120 VSS 0.03263f
C830 VDD.n121 VSS 0.07127f
C831 VDD.n122 VSS 0.0512f
C832 VDD.n123 VSS 0.05829f
C833 VDD.n124 VSS 0.01066f
C834 VDD.n125 VSS 0.06132f
C835 VDD.n126 VSS 0.06206f
C836 VDD.t12 VSS 0.01985f
C837 VDD.t17 VSS 0.01946f
C838 VDD.n127 VSS 0.03725f
C839 VDD.t94 VSS 0.01946f
C840 VDD.n128 VSS 0.0187f
C841 VDD.t111 VSS 0.01946f
C842 VDD.n129 VSS 0.03567f
C843 VDD.n130 VSS 0.47558f
C844 VDD.n131 VSS 0.17448f
C845 VDD.t13 VSS 0.01985f
C846 VDD.t18 VSS 0.01946f
C847 VDD.n132 VSS 0.03725f
C848 VDD.t95 VSS 0.01946f
C849 VDD.n133 VSS 0.0187f
C850 VDD.t112 VSS 0.01946f
C851 VDD.n134 VSS 0.01091f
C852 VDD.n135 VSS 0.01599f
C853 VDD.n136 VSS 0.0465f
C854 VDD.t0 VSS 4.98419f
C855 VDD.n137 VSS 0.57309f
C856 VDD.n138 VSS 0.01848f
C857 VDD.n139 VSS 0.06541f
C858 VDD.t92 VSS 0.01985f
C859 VDD.t28 VSS 0.01946f
C860 VDD.n140 VSS 0.03654f
C861 VDD.t75 VSS 0.01946f
C862 VDD.n141 VSS 0.01835f
C863 VDD.t81 VSS 0.01946f
C864 VDD.n142 VSS 0.01307f
C865 VDD.n143 VSS 0.13962f
C866 VDD.n144 VSS 0.47558f
C867 VDD.t88 VSS 0.06658f
C868 VDD.t56 VSS 0.03608f
C869 VDD.t57 VSS 0.06153f
C870 VDD.n145 VSS 0.03114f
C871 VDD.t55 VSS 0.06153f
C872 VDD.t54 VSS 0.03608f
C873 VDD.n146 VSS 0.03114f
C874 VDD.t1 VSS 8.10443f
C875 VDD.n147 VSS 0.52517f
C876 VDD.t73 VSS 0.06657f
C877 VDD.t86 VSS 0.06658f
C878 VDD.t64 VSS 0.03608f
C879 VDD.t65 VSS 0.06153f
C880 VDD.n148 VSS 0.03114f
C881 VDD.t49 VSS 0.06153f
C882 VDD.t48 VSS 0.03608f
C883 VDD.n149 VSS 0.03114f
C884 VDD.t8 VSS 0.06657f
C885 VDD.t36 VSS 0.06658f
C886 VDD.t25 VSS 0.06657f
C887 VDD.t40 VSS 0.06658f
C888 VDD.t23 VSS 0.06657f
C889 VDD.t35 VSS 0.06658f
C890 VDD.t16 VSS 0.06657f
C891 VDD.t115 VSS 0.06658f
C892 VDD.t38 VSS 0.06657f
C893 VDD.t128 VSS 0.06658f
C894 VDD.t37 VSS 0.06657f
C895 VDD.t34 VSS 0.06658f
C896 VDD.t104 VSS 0.06657f
C897 VDD.t24 VSS 0.06658f
C898 VDD.t122 VSS 0.07382f
C899 VDD.t6 VSS 0.07382f
C900 VDD.n150 VSS 0.30848f
C901 VDD.n151 VSS 0.18069f
C902 VDD.n152 VSS 0.01668f
C903 VDD.n153 VSS 0.08707f
C904 VDD.n154 VSS 0.01668f
C905 VDD.n155 VSS 0.07589f
C906 VDD.n156 VSS 0.01271f
C907 VDD.n157 VSS 0.09124f
C908 VDD.n158 VSS 0.03378f
C909 VDD.n159 VSS 0.10301f
C910 VDD.n160 VSS 0.01998f
C911 VDD.n161 VSS 0.08665f
C912 VDD.n162 VSS 0.0171f
C913 VDD.n163 VSS 0.09231f
C914 VDD.n164 VSS 0.01663f
C915 VDD.n165 VSS 0.09772f
C916 VDD.n166 VSS 0.02806f
C917 VDD.n167 VSS 0.06509f
C918 VDD.n168 VSS 0.02165f
C919 VDD.n169 VSS 0.10329f
C920 VDD.n170 VSS 0.02262f
C921 VDD.n171 VSS 0.08642f
C922 VDD.n172 VSS 0.07777f
C923 VDD.n173 VSS 0.72046f
C924 VDD.n174 VSS 1.08151f
C925 VDD.t58 VSS 0.03589f
C926 VDD.t59 VSS 0.06153f
C927 VDD.n176 VSS 0.0276f
C928 VDD.t53 VSS 0.06153f
C929 VDD.t52 VSS 0.03608f
C930 VDD.n177 VSS 0.03114f
C931 VDD.n178 VSS 0.07067f
C932 VDD.n179 VSS 0.02262f
C933 VDD.t26 VSS 0.06657f
C934 VDD.t47 VSS 0.06658f
C935 VDD.n180 VSS 0.10329f
C936 VDD.n181 VSS 0.02165f
C937 VDD.t50 VSS 0.03589f
C938 VDD.t51 VSS 0.06153f
C939 VDD.n182 VSS 0.0276f
C940 VDD.t67 VSS 0.06153f
C941 VDD.t66 VSS 0.03608f
C942 VDD.n183 VSS 0.03114f
C943 VDD.n184 VSS 0.06509f
C944 VDD.n185 VSS 0.02806f
C945 VDD.t83 VSS 0.06657f
C946 VDD.t68 VSS 0.06658f
C947 VDD.n186 VSS 0.09772f
C948 VDD.t76 VSS 0.06657f
C949 VDD.t96 VSS 0.06658f
C950 VDD.n187 VSS 0.09231f
C951 VDD.n188 VSS 0.01663f
C952 VDD.t124 VSS 0.06657f
C953 VDD.t110 VSS 0.06658f
C954 VDD.n189 VSS 0.08665f
C955 VDD.n190 VSS 0.01998f
C956 VDD.t31 VSS 0.06657f
C957 VDD.t39 VSS 0.06658f
C958 VDD.n191 VSS 0.10301f
C959 VDD.t10 VSS 0.06657f
C960 VDD.t29 VSS 0.06658f
C961 VDD.n192 VSS 0.09124f
C962 VDD.n193 VSS 0.03378f
C963 VDD.t82 VSS 0.06657f
C964 VDD.t71 VSS 0.06658f
C965 VDD.n194 VSS 0.07589f
C966 VDD.t77 VSS 0.06657f
C967 VDD.t19 VSS 0.06658f
C968 VDD.n195 VSS 0.08707f
C969 VDD.n196 VSS 0.01668f
C970 VDD.t9 VSS 8.11352f
C971 VDD.n197 VSS 0.57132f
C972 VDD.n198 VSS 0.30848f
C973 VDD.n199 VSS 1.08409f
C974 VDD.t121 VSS 0.06685f
C975 VDD.n200 VSS 0.0567f
C976 VDD.n201 VSS 0.20577f
C977 VDD.n202 VSS 0.06353f
C978 VDD.t4 VSS 6.22795f
C979 VDD.n204 VSS 0.51363f
C980 VDD.n205 VSS 0.01704f
C981 VX.t6 VSS 0.21861f
C982 VX.t5 VSS 0.19948f
C983 VX.n0 VSS 1.1074f
C984 VX.t1 VSS 0.25246f
C985 VX.t2 VSS 0.19948f
C986 VX.n1 VSS 1.32247f
C987 VX.t3 VSS 0.19948f
C988 VX.n2 VSS 0.37312f
C989 VX.n3 VSS 0.4806f
C990 VX.t4 VSS 0.27391f
C991 VX.n4 VSS 0.64269f
C992 VX.t0 VSS 0.95228f
C993 VX.n5 VSS 6.25592f
C994 MEM.n0 VSS 0.16687f
C995 MEM.t11 VSS 0.06564f
C996 MEM.t12 VSS 0.06269f
C997 MEM.n1 VSS 0.05724f
C998 MEM.n2 VSS 0.33269f
C999 MEM.n3 VSS 0.06998f
C1000 MEM.n4 VSS 0.37199f
C1001 MEM.n5 VSS 0.06998f
C1002 MEM.t0 VSS 0.03574f
C1003 MEM.n6 VSS 0.468f
C1004 MEM.n7 VSS 0.59543f
C1005 MEM.n8 VSS 0.38649f
C1006 MEM.n9 VSS 0.06998f
C1007 MEM.n10 VSS 0.38799f
C1008 MEM.n11 VSS 0.06998f
C1009 MEM.n12 VSS 0.06998f
C1010 MEM.n13 VSS 0.37152f
C1011 MEM.n14 VSS 0.38215f
C1012 MEM.n15 VSS 0.62631f
C1013 MEM.n16 VSS 0.19445f
C1014 VREF.t5 VSS 0.42626f
C1015 VREF.t4 VSS 0.38883f
C1016 VREF.n0 VSS 2.24089f
C1017 VREF.t3 VSS 0.38883f
C1018 VREF.n1 VSS 1.53908f
C1019 VREF.t1 VSS 0.38883f
C1020 VREF.n2 VSS 0.75261f
C1021 VREF.t0 VSS 0.48197f
C1022 VREF.n3 VSS 2.07638f
C1023 VREF.t2 VSS 0.45008f
C1024 VREF.n4 VSS 1.92628f
C1025 COMP.t0 VSS 0.19034f
C1026 COMP.t1 VSS 0.39829f
C1027 COMP.n0 VSS 0.30567f
C1028 COMP.t4 VSS 0.3343f
C1029 COMP.t3 VSS 0.30334f
C1030 COMP.n1 VSS 0.98839f
C1031 COMP.t2 VSS 1.36064f
C1032 COMP.n2 VSS 0.49108f
C1033 COMP.n3 VSS 0.22529f
C1034 RST.t0 VSS 0.6575f
C1035 SPIKE.t1 VSS 0.36061f
C1036 SPIKE.t0 VSS 0.15168f
C1037 SPIKE.n0 VSS 0.24228f
C1038 SPIKE.t2 VSS 0.13585f
C1039 SPIKE.t3 VSS 0.32894f
C1040 SPIKE.n1 VSS 0.23984f
C1041 SPIKE.n2 VSS 0.47753f
.ends
