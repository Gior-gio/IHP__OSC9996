* NGSPICE file created from LIF_neuron.ext - technology: ihp-sg13g2

.subckt LIF_neuron VDD Vx MEM RST SPIKE VSS Vref
X0 VSS.t78 VSS.t79 sub! rppd l=0.5u w=0.5u
X1 a_3521_6967# a_3317_6967# VSS.t81 VSS.t84 sg13_lv_nmos ad=0.34p pd=2.68u as=0.19p ps=1.38u w=1u l=0.13u
X2 VSS.t167 VSS.t168 sub! rppd l=0.5u w=0.5u
X3 VSS.t205 a_3545_4709# a_3207_4709# VSS.t89 sg13_lv_nmos ad=0.34p pd=2.68u as=0.34p ps=2.68u w=1u l=0.65u
X4 a_3317_6967# a_2907_6967# VSS.t192 VSS.t93 sg13_lv_nmos ad=0.34p pd=2.68u as=0.34p ps=2.68u w=1u l=0.13u
X5 a_1369_6967# a_1267_8081# a_1267_6967# VDD.t6 sg13_lv_pmos ad=0.38p pd=2.38u as=0.38p ps=2.38u w=2u l=0.13u
X6 a_2907_10309# a_2584_10309# a_2805_10831# VDD.t13 sg13_lv_pmos ad=0.38p pd=2.38u as=0.38p ps=2.38u w=2u l=0.13u
X7 a_1369_10309# a_1267_5853.t2 a_1267_10309# VSS.t159 sg13_lv_nmos ad=0.19p pd=1.38u as=0.19p ps=1.38u w=1u l=0.13u
X8 VDD.t74 a_917_8508.t3 a_1369_9195# VDD.t4 sg13_lv_pmos ad=0.68p pd=4.68u as=0.38p ps=2.38u w=2u l=0.13u
X9 a_2907_6967# a_2584_6967# a_2805_6967# VDD.t6 sg13_lv_pmos ad=0.38p pd=2.38u as=0.38p ps=2.38u w=2u l=0.13u
X10 VSS.t12 VSS.t13 sub! rppd l=0.5u w=0.5u
X11 VDD.t70 VDD.t71 sub! rhigh l=4u w=0.5u
X12 a_3009_9195# a_1267_9195# a_2907_9195# VDD.t4 sg13_lv_pmos ad=0.38p pd=2.38u as=0.38p ps=2.38u w=2u l=0.13u
X13 a_1839_8081# VDD.t65 VDD.t66 VDD.t4 sg13_lv_pmos ad=0.38p pd=2.38u as=0.68p ps=4.68u w=2u l=0.13u
X14 a_1267_5853.t0 Ven VSS.t11 VSS.t10 sg13_lv_nmos ad=0.19p pd=1.38u as=0.34p ps=2.68u w=1u l=0.13u
X15 a_1369_8081# a_1267_9195# a_1267_8081# VSS.t166 sg13_lv_nmos ad=0.19p pd=1.38u as=0.19p ps=1.38u w=1u l=0.13u
X16 VDD.t38 vCMP.t2 a_4221_4709# VDD.t2 sg13_lv_pmos ad=0.68p pd=4.68u as=0.68p ps=4.68u w=2u l=0.65u
X17 VDD.t5 a_3883_4709# a_3545_4709# VDD.t2 sg13_lv_pmos ad=0.68p pd=4.68u as=0.68p ps=4.68u w=2u l=0.65u
X18 a_2907_8081# a_1267_8081# a_2805_8081# VSS.t145 sg13_lv_nmos ad=0.19p pd=1.38u as=0.19p ps=1.38u w=1u l=0.13u
X19 VSS.t233 Ven.t6 a_1692_4709# VSS.t232 sg13_lv_nmos ad=0.34p pd=2.68u as=0.19p ps=1.38u w=1u l=0.13u
X20 VSS.t110 VSS.t111 sub! rppd l=0.5u w=0.5u
X21 VSS.t137 a_4828_5366# vCMP.t0 VSS.t136 sg13_lv_nmos ad=0.19p pd=1.38u as=0.19p ps=1.38u w=1u l=0.13u
X22 a_3521_6967# a_3317_6967# VDD.t18 VDD.t6 sg13_lv_pmos ad=0.68p pd=4.68u as=0.38p ps=2.38u w=2u l=0.13u
X23 a_3521_10309# a_3317_10309# VSS.t230 VSS.t218 sg13_lv_nmos ad=0.19p pd=1.38u as=0.34p ps=2.68u w=1u l=0.13u
X24 VDD.t73 a_2538_4709# a_2130_4709# VDD.t2 sg13_lv_pmos ad=0.68p pd=4.68u as=0.68p ps=4.68u w=2u l=0.13u
X25 a_1902_11577# a_2788_11753# sub! rhigh l=4u w=0.5u
X26 a_3992_11577# VOUT.t0 sub! rhigh l=4u w=0.5u
X27 a_2584_10309# a_1267_10309# VSS.t172 VSS.t164 sg13_lv_nmos ad=0.34p pd=2.68u as=0.34p ps=2.68u w=1u l=0.13u
X28 a_3317_6967# a_2907_6967# VDD.t85 VDD.t6 sg13_lv_pmos ad=0.68p pd=4.68u as=0.68p ps=4.68u w=2u l=0.13u
X29 a_1839_9195# VSS.t76 VSS.t77 VSS.t8 sg13_lv_nmos ad=0.19p pd=1.38u as=0.34p ps=2.68u w=1u l=0.13u
X30 VDD.t43 a_2130_4709# SPIKE.t3 VDD.t2 sg13_lv_pmos ad=0.38p pd=2.38u as=0.68p ps=4.68u w=2u l=0.13u
X31 VSS.t88 a_3317_5853# a_3521_5853# VSS.t89 sg13_lv_nmos ad=0.19p pd=1.38u as=0.19p ps=1.38u w=1u l=0.13u
X32 VSS.t247 VSS.t248 sub! rppd l=0.5u w=0.5u
X33 a_1267_8081# VDD.t63 VDD.t64 VDD.t4 sg13_lv_pmos ad=0.38p pd=2.38u as=0.68p ps=4.68u w=2u l=0.13u
X34 a_3521_8081# a_3317_8081# VSS.t90 VSS.t84 sg13_lv_nmos ad=0.34p pd=2.68u as=0.19p ps=1.38u w=1u l=0.13u
X35 VSS.t108 VSS.t109 sub! rppd l=0.5u w=0.5u
X36 a_2805_10309# a_1839_10309# VSS.t237 VSS.t236 sg13_lv_nmos ad=0.19p pd=1.38u as=0.34p ps=2.68u w=1u l=0.13u
X37 a_3317_8081# a_2907_8081# VSS.t94 VSS.t93 sg13_lv_nmos ad=0.34p pd=2.68u as=0.34p ps=2.68u w=1u l=0.13u
X38 Ven a_1071_4709# VSS.t239 VSS.t242 sg13_lv_nmos ad=0.19p pd=1.38u as=0.19p ps=1.38u w=1u l=0.13u
X39 VSS.t28 a_2380_5853# a_3009_5853# VSS.t27 sg13_lv_nmos ad=0.34p pd=2.68u as=0.19p ps=1.38u w=1u l=0.13u
X40 VSS.t214 VSS.t215 sub! rppd l=0.5u w=0.5u
X41 VSS.t36 VSS.t37 sub! rppd l=0.5u w=0.5u
X42 a_2584_5853# a_1267_5853.t3 VSS.t161 VSS.t160 sg13_lv_nmos ad=0.34p pd=2.68u as=0.34p ps=2.68u w=1u l=0.13u
X43 VSS.t16 VSS.t17 sub! rppd l=0.5u w=0.5u
X44 VDD.t112 a_917_8508.t4 a_1369_6375# VDD.t6 sg13_lv_pmos ad=0.68p pd=4.68u as=0.38p ps=2.38u w=2u l=0.13u
X45 a_2380_9195# a_1839_9195# VDD.t110 VDD.t4 sg13_lv_pmos ad=0.68p pd=4.68u as=0.68p ps=4.68u w=2u l=0.13u
X46 a_3009_6375# a_1267_5853.t4 a_2907_5853# VDD.t6 sg13_lv_pmos ad=0.38p pd=2.38u as=0.38p ps=2.38u w=2u l=0.13u
X47 a_3521_8081# VOUT.t9 sub! rppd l=0.5u w=0.5u
X48 a_1839_10309# VDD.t61 VDD.t62 VDD.t13 sg13_lv_pmos ad=0.38p pd=2.38u as=0.68p ps=4.68u w=2u l=0.13u
X49 a_1692_4709# Ven.t6 a_1820_4745# VDD.t2 sg13_lv_pmos ad=0.68p pd=4.68u as=0.38p ps=2.38u w=2u l=0.13u
X50 VSS.t107 VOUT.t11 a_4828_5366# VSS.t106 sg13_lv_nmos ad=0.34p pd=2.68u as=0.19p ps=1.38u w=1u l=0.13u
X51 VSS.t113 VSS.t114 sub! rppd l=0.5u w=0.5u
X52 a_1267_9195# VSS.t74 VSS.t75 VSS.t6 sg13_lv_nmos ad=0.19p pd=1.38u as=0.34p ps=2.68u w=1u l=0.13u
X53 VSS.t175 VSS.t176 sub! rppd l=0.5u w=0.5u
X54 VDD.t25 a_3317_8081# a_3521_8081# VDD.t4 sg13_lv_pmos ad=0.38p pd=2.38u as=0.38p ps=2.38u w=2u l=0.13u
X55 a_2907_10309# a_1267_10309# a_2805_10309# VSS.t163 sg13_lv_nmos ad=0.19p pd=1.38u as=0.19p ps=1.38u w=1u l=0.13u
X56 VDD.t113 a_917_8508.t5 a_1369_10831# VDD.t13 sg13_lv_pmos ad=0.68p pd=4.68u as=0.38p ps=2.38u w=2u l=0.13u
X57 VDD.t11 a_2380_8081# a_3009_8603# VDD.t4 sg13_lv_pmos ad=0.68p pd=4.68u as=0.38p ps=2.38u w=2u l=0.13u
X58 VSS.t182 Vctr.t1 a_1369_7689# VSS.t181 sg13_lv_nmos ad=0.34p pd=2.68u as=0.19p ps=1.38u w=1u l=0.13u
X59 VDD.t111 vCMP.t3 a_2769_4709# VDD.t2 sg13_lv_pmos ad=0.68p pd=4.68u as=0.38p ps=2.38u w=2u l=0.13u
X60 a_2584_8081# a_1267_8081# VDD.t99 VDD.t4 sg13_lv_pmos ad=0.68p pd=4.68u as=0.68p ps=4.68u w=2u l=0.13u
X61 a_3009_7689# a_2584_6967# a_2907_6967# VSS.t186 sg13_lv_nmos ad=0.19p pd=1.38u as=0.19p ps=1.38u w=1u l=0.13u
X62 a_1941_5853# a_1839_6967# a_1839_5853.t0 VSS.t63 sg13_lv_nmos ad=0.19p pd=1.38u as=0.19p ps=1.38u w=1u l=0.13u
X63 VSS.t119 VSS.t120 sub! rppd l=0.5u w=0.5u
X64 VSS.t221 a_3317_9195# a_3521_9195# VSS.t222 sg13_lv_nmos ad=0.19p pd=1.38u as=0.19p ps=1.38u w=1u l=0.13u
X65 a_917_8508.t1 a_917_8508.t0 VDD.t69 VDD.t4 sg13_lv_pmos ad=0.68p pd=4.68u as=0.68p ps=4.68u w=2u l=0.13u
X66 VSS.t193 VSS.t194 sub! rppd l=0.5u w=0.5u
X67 Ven a_1071_4709# VDD.t105 VDD.t2 sg13_lv_pmos ad=0.38p pd=2.38u as=0.38p ps=2.38u w=2u l=0.13u
X68 VDD.t97 a_3317_10309# a_3521_10309# VDD.t13 sg13_lv_pmos ad=0.38p pd=2.38u as=0.38p ps=2.38u w=2u l=0.13u
X69 SPIKE.t1 a_2130_4709# VSS.t141 VSS.t144 sg13_lv_nmos ad=0.19p pd=1.38u as=0.19p ps=1.38u w=1u l=0.13u
X70 a_2380_5853# a_1839_5853.t2 VDD.t28 VDD.t6 sg13_lv_pmos ad=0.68p pd=4.68u as=0.68p ps=4.68u w=2u l=0.13u
X71 VSS.t189 a_2380_9195# a_3009_9917# VSS.t57 sg13_lv_nmos ad=0.34p pd=2.68u as=0.19p ps=1.38u w=1u l=0.13u
X72 VSS.t38 VSS.t39 sub! rppd l=0.5u w=0.5u
X73 a_2584_9195# a_1267_9195# VSS.t165 VSS.t164 sg13_lv_nmos ad=0.34p pd=2.68u as=0.34p ps=2.68u w=1u l=0.13u
X74 VDD.t114 a_917_8508.t6 a_1369_6967# VDD.t6 sg13_lv_pmos ad=0.68p pd=4.68u as=0.38p ps=2.38u w=2u l=0.13u
X75 VSS.t223 VSS.t224 sub! rppd l=0.5u w=0.5u
X76 a_3009_6967# a_1267_6967# a_2907_6967# VDD.t6 sg13_lv_pmos ad=0.38p pd=2.38u as=0.38p ps=2.38u w=2u l=0.13u
X77 VSS.t191 a_4221_4709# a_3883_4709# VSS.t190 sg13_lv_nmos ad=0.34p pd=2.68u as=0.34p ps=2.68u w=1u l=0.65u
X78 VDD.t31 VDD.t32 sub! rhigh l=4u w=0.5u
X79 a_2805_9195# a_1839_9195# VDD.t109 VDD.t4 sg13_lv_pmos ad=0.38p pd=2.38u as=0.68p ps=4.68u w=2u l=0.13u
X80 a_1941_8603# a_1839_9195# a_1839_8081# VDD.t4 sg13_lv_pmos ad=0.38p pd=2.38u as=0.38p ps=2.38u w=2u l=0.13u
X81 a_1369_5853# a_1267_6967# a_1267_5853.t0 VSS.t148 sg13_lv_nmos ad=0.19p pd=1.38u as=0.19p ps=1.38u w=1u l=0.13u
X82 VDD.t86 a_917_6931.t3 a_1941_9195# VDD.t4 sg13_lv_pmos ad=0.68p pd=4.68u as=0.38p ps=2.38u w=2u l=0.13u
X83 VSS.t183 Vctr.t2 a_1369_8081# VSS.t181 sg13_lv_nmos ad=0.34p pd=2.68u as=0.19p ps=1.38u w=1u l=0.13u
X84 a_2907_5853# a_1267_5853.t5 a_2805_5853# VSS.t112 sg13_lv_nmos ad=0.19p pd=1.38u as=0.19p ps=1.38u w=1u l=0.13u
X85 VSS.t23 VSS.t24 sub! rppd l=0.5u w=0.5u
X86 a_1839_10309# Ven VSS.t9 VSS.t8 sg13_lv_nmos ad=0.19p pd=1.38u as=0.34p ps=2.68u w=1u l=0.13u
X87 a_3009_8081# a_2584_8081# a_2907_8081# VSS.t186 sg13_lv_nmos ad=0.19p pd=1.38u as=0.19p ps=1.38u w=1u l=0.13u
X88 a_2380_6967# a_1839_6967# VSS.t62 VSS.t61 sg13_lv_nmos ad=0.34p pd=2.68u as=0.34p ps=2.68u w=1u l=0.13u
X89 a_3317_10309# a_2907_10309# VDD.t75 VDD.t13 sg13_lv_pmos ad=0.68p pd=4.68u as=0.68p ps=4.68u w=2u l=0.13u
X90 a_3521_9195# VOUT.t6 sub! rppd l=0.5u w=0.5u
X91 a_856_11577# a_1742_11577# sub! rhigh l=4u w=0.5u
X92 a_2380_10309# a_1839_10309# VDD.t104 VDD.t13 sg13_lv_pmos ad=0.68p pd=4.68u as=0.68p ps=4.68u w=2u l=0.13u
X93 a_3009_10831# a_1267_10309# a_2907_10309# VDD.t13 sg13_lv_pmos ad=0.38p pd=2.38u as=0.38p ps=2.38u w=2u l=0.13u
X94 VSS.t210 Vctr.t3 a_1369_10309# VSS.t209 sg13_lv_nmos ad=0.34p pd=2.68u as=0.19p ps=1.38u w=1u l=0.13u
X95 VSS.t54 VSS.t55 sub! rppd l=0.5u w=0.5u
X96 a_3521_5853# a_3317_5853# VSS.t88 VSS.t87 sg13_lv_nmos ad=0.34p pd=2.68u as=0.19p ps=1.38u w=1u l=0.13u
X97 a_1941_9917# a_1839_10309# a_1839_9195# VSS.t208 sg13_lv_nmos ad=0.19p pd=1.38u as=0.19p ps=1.38u w=1u l=0.13u
X98 a_3521_9195# a_3317_9195# VDD.t94 VDD.t4 sg13_lv_pmos ad=0.38p pd=2.38u as=0.68p ps=4.68u w=2u l=0.13u
X99 SPIKE.t2 a_2130_4709# VDD.t43 VDD.t2 sg13_lv_pmos ad=0.38p pd=2.38u as=0.38p ps=2.38u w=2u l=0.13u
X100 a_1369_8603# a_1267_9195# a_1267_8081# VDD.t4 sg13_lv_pmos ad=0.38p pd=2.38u as=0.38p ps=2.38u w=2u l=0.13u
X101 a_3317_5853# a_2907_5853# VSS.t127 VSS.t126 sg13_lv_nmos ad=0.34p pd=2.68u as=0.34p ps=2.68u w=1u l=0.13u
X102 a_2907_8081# a_2584_8081# a_2805_8603# VDD.t4 sg13_lv_pmos ad=0.38p pd=2.38u as=0.38p ps=2.38u w=2u l=0.13u
X103 VSS.t241 a_1071_4709# Ven VSS.t240 sg13_lv_nmos ad=0.34p pd=2.68u as=0.19p ps=1.38u w=1u l=0.13u
X104 VSS.t64 VSS.t65 sub! rppd l=0.5u w=0.5u
X105 VSS.t179 VSS.t180 sub! rppd l=0.5u w=0.5u
X106 a_2380_6967# a_1839_6967# VDD.t16 VDD.t6 sg13_lv_pmos ad=0.68p pd=4.68u as=0.68p ps=4.68u w=2u l=0.13u
X107 a_2788_11753# a_3837_11577# sub! rhigh l=4u w=0.5u
X108 VSS.t104 VSS.t105 sub! rppd l=0.5u w=0.5u
X109 a_2805_6375# a_1839_5853.t3 VDD.t89 VDD.t6 sg13_lv_pmos ad=0.38p pd=2.38u as=0.68p ps=4.68u w=2u l=0.13u
X110 VSS.t228 a_3317_10309# a_3521_10309# VSS.t222 sg13_lv_nmos ad=0.19p pd=1.38u as=0.19p ps=1.38u w=1u l=0.13u
X111 a_2380_8081# a_1839_8081# VSS.t125 VSS.t61 sg13_lv_nmos ad=0.34p pd=2.68u as=0.34p ps=2.68u w=1u l=0.13u
X112 VDD.t87 a_917_6931.t4 a_1941_6375# VDD.t6 sg13_lv_pmos ad=0.68p pd=4.68u as=0.38p ps=2.38u w=2u l=0.13u
X113 VSS.t173 VSS.t174 sub! rppd l=0.5u w=0.5u
X114 a_3521_8081# a_3317_8081# VDD.t25 VDD.t4 sg13_lv_pmos ad=0.68p pd=4.68u as=0.38p ps=2.38u w=2u l=0.13u
X115 a_1369_9917# a_1267_10309# a_1267_9195# VSS.t159 sg13_lv_nmos ad=0.19p pd=1.38u as=0.19p ps=1.38u w=1u l=0.13u
X116 a_2907_9195# a_1267_9195# a_2805_9917# VSS.t163 sg13_lv_nmos ad=0.19p pd=1.38u as=0.19p ps=1.38u w=1u l=0.13u
X117 VSS.t69 a_3207_4709# a_2840_5276# VSS.t68 sg13_lv_nmos ad=0.34p pd=2.68u as=0.34p ps=2.68u w=1u l=0.65u
X118 VSS.t34 VSS.t35 sub! rppd l=0.5u w=0.5u
X119 a_3317_8081# a_2907_8081# VDD.t27 VDD.t4 sg13_lv_pmos ad=0.68p pd=4.68u as=0.68p ps=4.68u w=2u l=0.13u
X120 VDD.t0 VDD.t1 sub! rhigh l=4u w=0.5u
X121 VDD.t10 a_2769_4709# a_2538_4709# VDD.t2 sg13_lv_pmos ad=0.38p pd=2.38u as=0.68p ps=4.68u w=2u l=0.13u
X122 a_3992_11577# a_2951_11577# sub! rhigh l=4u w=0.5u
X123 a_2805_7689# a_1839_6967# VSS.t60 VSS.t59 sg13_lv_nmos ad=0.19p pd=1.38u as=0.34p ps=2.68u w=1u l=0.13u
X124 VSS.t66 VSS.t67 sub! rppd l=0.5u w=0.5u
X125 a_3521_5853# a_3317_5853# VDD.t23 VDD.t6 sg13_lv_pmos ad=0.38p pd=2.38u as=0.68p ps=4.68u w=2u l=0.13u
X126 a_1902_11577# a_856_11577# sub! rhigh l=4u w=0.5u
X127 a_3317_10309# a_2907_10309# VSS.t171 VSS.t157 sg13_lv_nmos ad=0.34p pd=2.68u as=0.34p ps=2.68u w=1u l=0.13u
X128 VSS.t226 VSS.t227 sub! rppd l=0.5u w=0.5u
X129 VSS.t150 Vref.t0 a_1941_7689# VSS.t149 sg13_lv_nmos ad=0.34p pd=2.68u as=0.19p ps=1.38u w=1u l=0.13u
X130 VDD.t88 a_3545_4709# a_3207_4709# VDD.t2 sg13_lv_pmos ad=0.68p pd=4.68u as=0.68p ps=4.68u w=2u l=0.65u
X131 a_1941_10831# a_1839_5853.t4 a_1839_10309# VDD.t13 sg13_lv_pmos ad=0.38p pd=2.38u as=0.38p ps=2.38u w=2u l=0.13u
X132 a_2380_10309# a_1839_10309# VSS.t235 VSS.t234 sg13_lv_nmos ad=0.34p pd=2.68u as=0.34p ps=2.68u w=1u l=0.13u
X133 a_1839_9195# VDD.t59 VDD.t60 VDD.t4 sg13_lv_pmos ad=0.38p pd=2.38u as=0.68p ps=4.68u w=2u l=0.13u
X134 VDD.t79 VDD.t80 sub! rhigh l=4u w=0.5u
X135 VDD.t8 VDD.t9 sub! rhigh l=4u w=0.5u
X136 VSS.t115 VSS.t116 sub! rppd l=0.5u w=0.5u
X137 a_3521_9195# a_3317_9195# VSS.t221 VSS.t220 sg13_lv_nmos ad=0.34p pd=2.68u as=0.19p ps=1.38u w=1u l=0.13u
X138 a_3521_9195# VOUT.t3 sub! rppd l=0.5u w=0.5u
X139 VDD.t106 a_1071_4709# Ven VDD.t2 sg13_lv_pmos ad=0.68p pd=4.68u as=0.38p ps=2.38u w=2u l=0.13u
X140 VSS.t143 a_2130_4709# SPIKE.t1 VSS.t142 sg13_lv_nmos ad=0.34p pd=2.68u as=0.19p ps=1.38u w=1u l=0.13u
X141 a_3009_10309# a_2584_10309# a_2907_10309# VSS.t22 sg13_lv_nmos ad=0.19p pd=1.38u as=0.19p ps=1.38u w=1u l=0.13u
X142 VSS.t40 VSS.t41 sub! rppd l=0.5u w=0.5u
X143 a_3317_9195# a_2907_9195# VSS.t158 VSS.t157 sg13_lv_nmos ad=0.34p pd=2.68u as=0.34p ps=2.68u w=1u l=0.13u
X144 a_2897_5460# a_2840_5276# VSS.t45 VSS.t44 sg13_lv_nmos ad=0.19p pd=1.38u as=0.19p ps=1.38u w=1u l=0.13u
X145 VSS.t18 VSS.t19 sub! rppd l=0.5u w=0.5u
X146 a_3521_5853# VOUT.t4 sub! rppd l=0.5u w=0.5u
X147 a_3521_6967# a_3317_6967# VSS.t83 VSS.t82 sg13_lv_nmos ad=0.19p pd=1.38u as=0.34p ps=2.68u w=1u l=0.13u
X148 a_2805_6967# a_1839_6967# VDD.t15 VDD.t6 sg13_lv_pmos ad=0.38p pd=2.38u as=0.68p ps=4.68u w=2u l=0.13u
X149 VDD.t100 a_917_6931.t5 a_1941_6967# VDD.t6 sg13_lv_pmos ad=0.68p pd=4.68u as=0.38p ps=2.38u w=2u l=0.13u
X150 VSS.t212 Vctr.t4 a_1369_5853# VSS.t211 sg13_lv_nmos ad=0.34p pd=2.68u as=0.19p ps=1.38u w=1u l=0.13u
X151 VDD.t14 a_2380_10309# a_3009_10831# VDD.t13 sg13_lv_pmos ad=0.68p pd=4.68u as=0.38p ps=2.38u w=2u l=0.13u
X152 a_1267_9195# VDD.t57 VDD.t58 VDD.t4 sg13_lv_pmos ad=0.38p pd=2.38u as=0.68p ps=4.68u w=2u l=0.13u
X153 a_3009_5853# a_2584_5853# a_2907_5853# VSS.t33 sg13_lv_nmos ad=0.19p pd=1.38u as=0.19p ps=1.38u w=1u l=0.13u
X154 VSS.t121 VSS.t122 sub! rppd l=0.5u w=0.5u
X155 a_3521_10309# a_3317_10309# VDD.t97 VDD.t13 sg13_lv_pmos ad=0.68p pd=4.68u as=0.38p ps=2.38u w=2u l=0.13u
X156 a_2805_8081# a_1839_8081# VSS.t124 VSS.t59 sg13_lv_nmos ad=0.19p pd=1.38u as=0.34p ps=2.68u w=1u l=0.13u
X157 a_3521_10309# VOUT.t2 sub! rppd l=0.5u w=0.5u
X158 VSS.t151 Vref.t1 a_1941_8081# VSS.t149 sg13_lv_nmos ad=0.34p pd=2.68u as=0.19p ps=1.38u w=1u l=0.13u
X159 VSS.t133 a_1692_4709# a_1479_4709# VSS.t243 sg13_lv_nmos ad=0.19p pd=1.38u as=0.34p ps=2.68u w=1u l=0.13u
X160 a_1267_10309# VDD.t55 VDD.t56 VDD.t13 sg13_lv_pmos ad=0.38p pd=2.38u as=0.68p ps=4.68u w=2u l=0.13u
X161 a_1839_5853.t1 VDD.t53 VDD.t54 VDD.t6 sg13_lv_pmos ad=0.38p pd=2.38u as=0.68p ps=4.68u w=2u l=0.13u
X162 VSS.t199 VSS.t200 sub! rppd l=0.5u w=0.5u
X163 a_3521_6967# a_3317_6967# VDD.t19 VDD.t6 sg13_lv_pmos ad=0.38p pd=2.38u as=0.68p ps=4.68u w=2u l=0.13u
X164 VDD.t92 a_3317_9195# a_3521_9195# VDD.t4 sg13_lv_pmos ad=0.38p pd=2.38u as=0.38p ps=2.38u w=2u l=0.13u
X165 VSS.t216 VSS.t217 sub! rppd l=0.5u w=0.5u
X166 VSS.t46 VSS.t47 sub! rppd l=0.5u w=0.5u
X167 VDD.t42 a_2130_4709# SPIKE.t2 VDD.t2 sg13_lv_pmos ad=0.68p pd=4.68u as=0.38p ps=2.38u w=2u l=0.13u
X168 VSS.t187 VSS.t188 sub! rppd l=0.5u w=0.5u
X169 VDD.t81 a_917_8508.t7 a_1369_8603# VDD.t4 sg13_lv_pmos ad=0.68p pd=4.68u as=0.38p ps=2.38u w=2u l=0.13u
X170 VSS.t131 vCMP.t2 a_4221_4709# VSS.t130 sg13_lv_nmos ad=0.34p pd=2.68u as=0.34p ps=2.68u w=1u l=0.65u
X171 VSS.t26 a_3883_4709# a_3545_4709# VSS.t25 sg13_lv_nmos ad=0.34p pd=2.68u as=0.34p ps=2.68u w=1u l=0.65u
X172 a_3009_8603# a_1267_8081# a_2907_8081# VDD.t4 sg13_lv_pmos ad=0.38p pd=2.38u as=0.38p ps=2.38u w=2u l=0.13u
X173 a_1941_10309# a_1839_5853.t4 a_1839_10309# VSS.t208 sg13_lv_nmos ad=0.19p pd=1.38u as=0.19p ps=1.38u w=1u l=0.13u
X174 a_3521_8081# a_3317_8081# VSS.t91 VSS.t82 sg13_lv_nmos ad=0.19p pd=1.38u as=0.34p ps=2.68u w=1u l=0.13u
X175 a_2584_9195# a_1267_9195# VDD.t72 VDD.t4 sg13_lv_pmos ad=0.68p pd=4.68u as=0.68p ps=4.68u w=2u l=0.13u
X176 VDD.t82 a_2380_9195# a_3009_9195# VDD.t4 sg13_lv_pmos ad=0.68p pd=4.68u as=0.38p ps=2.38u w=2u l=0.13u
X177 vCMP.t1 a_4828_5366# VDD.t41 VDD.t2 sg13_lv_pmos ad=0.38p pd=2.38u as=0.68p ps=4.68u w=2u l=0.13u
X178 VSS.t195 VSS.t196 sub! rppd l=0.5u w=0.5u
X179 a_3521_10309# VOUT.t1 sub! rppd l=0.5u w=0.5u
X180 VSS.t42 VSS.t43 sub! rppd l=0.5u w=0.5u
X181 a_1839_6967# VSS.t72 VSS.t73 VSS.t4 sg13_lv_nmos ad=0.19p pd=1.38u as=0.34p ps=2.68u w=1u l=0.13u
X182 VSS.t50 VSS.t51 sub! rppd l=0.5u w=0.5u
X183 a_2380_5853# a_1839_5853.t2 VSS.t96 VSS.t95 sg13_lv_nmos ad=0.34p pd=2.68u as=0.34p ps=2.68u w=1u l=0.13u
X184 a_1267_5853.t1 VDD.t51 VDD.t52 VDD.t6 sg13_lv_pmos ad=0.38p pd=2.38u as=0.68p ps=4.68u w=2u l=0.13u
X185 VSS.t14 VSS.t15 sub! rppd l=0.5u w=0.5u
X186 VDD.t101 a_917_6931.t6 a_1941_10831# VDD.t13 sg13_lv_pmos ad=0.68p pd=4.68u as=0.38p ps=2.38u w=2u l=0.13u
X187 VSS.t213 Vctr.t5 a_1369_9917# VSS.t209 sg13_lv_nmos ad=0.34p pd=2.68u as=0.19p ps=1.38u w=1u l=0.13u
X188 a_3009_9917# a_2584_9195# a_2907_9195# VSS.t22 sg13_lv_nmos ad=0.19p pd=1.38u as=0.19p ps=1.38u w=1u l=0.13u
X189 VDD.t39 a_1692_4709# a_1479_4709# VDD.t2 sg13_lv_pmos ad=0.38p pd=2.38u as=0.68p ps=4.68u w=2u l=0.13u
X190 VDD.t77 VDD.t78 sub! rhigh l=4u w=0.5u
X191 VSS.t58 a_2380_10309# a_3009_10309# VSS.t57 sg13_lv_nmos ad=0.34p pd=2.68u as=0.19p ps=1.38u w=1u l=0.13u
X192 VDD.t21 a_3317_5853# a_3521_5853# VDD.t6 sg13_lv_pmos ad=0.38p pd=2.38u as=0.38p ps=2.38u w=2u l=0.13u
X193 VSS.t52 VSS.t53 sub! rppd l=0.5u w=0.5u
X194 a_3521_10309# a_3317_10309# VSS.t228 VSS.t220 sg13_lv_nmos ad=0.34p pd=2.68u as=0.19p ps=1.38u w=1u l=0.13u
X195 VSS.t31 VSS.t32 sub! rppd l=0.5u w=0.5u
X196 a_1267_6967# VSS.t70 VSS.t71 VSS.t2 sg13_lv_nmos ad=0.19p pd=1.38u as=0.34p ps=2.68u w=1u l=0.13u
X197 VSS.t177 VSS.t178 sub! rppd l=0.5u w=0.5u
X198 a_1839_6967# VDD.t49 VDD.t50 VDD.t6 sg13_lv_pmos ad=0.38p pd=2.38u as=0.68p ps=4.68u w=2u l=0.13u
X199 a_1941_9195# a_1839_10309# a_1839_9195# VDD.t4 sg13_lv_pmos ad=0.38p pd=2.38u as=0.38p ps=2.38u w=2u l=0.13u
X200 a_2380_8081# a_1839_8081# VDD.t34 VDD.t4 sg13_lv_pmos ad=0.68p pd=4.68u as=0.68p ps=4.68u w=2u l=0.13u
X201 a_4828_5366# VOUT.t12 VDD.t40 VDD.t2 sg13_lv_pmos ad=0.38p pd=2.38u as=0.38p ps=2.38u w=2u l=0.13u
X202 a_1267_10309# Ven VSS.t7 VSS.t6 sg13_lv_nmos ad=0.19p pd=1.38u as=0.34p ps=2.68u w=1u l=0.13u
X203 VSS.t117 VSS.t118 sub! rppd l=0.5u w=0.5u
X204 VDD.t84 a_4221_4709# a_3883_4709# VDD.t2 sg13_lv_pmos ad=0.68p pd=4.68u as=0.68p ps=4.68u w=2u l=0.65u
X205 VDD.t7 a_2380_5853# a_3009_6375# VDD.t6 sg13_lv_pmos ad=0.68p pd=4.68u as=0.38p ps=2.38u w=2u l=0.13u
X206 VSS.t249 VSS.t250 sub! rppd l=0.5u w=0.5u
X207 a_1839_8081# Ven VSS.t5 VSS.t4 sg13_lv_nmos ad=0.19p pd=1.38u as=0.34p ps=2.68u w=1u l=0.13u
X208 a_3521_5853# VOUT.t7 sub! rppd l=0.5u w=0.5u
X209 a_2584_5853# a_1267_5853.t3 VDD.t68 VDD.t6 sg13_lv_pmos ad=0.68p pd=4.68u as=0.68p ps=4.68u w=2u l=0.13u
X210 a_2951_11577# a_3837_11577# sub! rhigh l=4u w=0.5u
X211 a_2769_4709# vCMP.t3 a_2897_5460# VSS.t246 sg13_lv_nmos ad=0.34p pd=2.68u as=0.19p ps=1.38u w=1u l=0.13u
X212 VSS.t81 a_3317_6967# a_3521_6967# VSS.t80 sg13_lv_nmos ad=0.19p pd=1.38u as=0.19p ps=1.38u w=1u l=0.13u
X213 a_3521_6967# VOUT.t10 sub! rppd l=0.5u w=0.5u
X214 a_2380_9195# a_1839_9195# VSS.t245 VSS.t234 sg13_lv_nmos ad=0.34p pd=2.68u as=0.34p ps=2.68u w=1u l=0.13u
X215 a_1267_6967# VDD.t47 VDD.t48 VDD.t6 sg13_lv_pmos ad=0.38p pd=2.38u as=0.68p ps=4.68u w=2u l=0.13u
X216 a_1369_9195# a_1267_10309# a_1267_9195# VDD.t4 sg13_lv_pmos ad=0.38p pd=2.38u as=0.38p ps=2.38u w=2u l=0.13u
X217 a_2907_9195# a_2584_9195# a_2805_9195# VDD.t4 sg13_lv_pmos ad=0.38p pd=2.38u as=0.38p ps=2.38u w=2u l=0.13u
X218 VSS.t128 VSS.t129 sub! rppd l=0.5u w=0.5u
X219 VSS.t56 a_2380_6967# a_3009_7689# VSS.t48 sg13_lv_nmos ad=0.34p pd=2.68u as=0.19p ps=1.38u w=1u l=0.13u
X220 a_2805_5853# a_1839_5853.t3 VSS.t207 VSS.t206 sg13_lv_nmos ad=0.19p pd=1.38u as=0.34p ps=2.68u w=1u l=0.13u
X221 a_2584_6967# a_1267_6967# VSS.t147 VSS.t146 sg13_lv_nmos ad=0.34p pd=2.68u as=0.34p ps=2.68u w=1u l=0.13u
X222 VSS.t153 Vref.t2 a_1941_5853# VSS.t152 sg13_lv_nmos ad=0.34p pd=2.68u as=0.19p ps=1.38u w=1u l=0.13u
X223 VSS.t197 VSS.t198 sub! rppd l=0.5u w=0.5u
X224 a_1267_8081# Ven VSS.t3 VSS.t2 sg13_lv_nmos ad=0.19p pd=1.38u as=0.34p ps=2.68u w=1u l=0.13u
X225 a_1692_4709# vCMP.t4 VSS.t133 VSS.t132 sg13_lv_nmos ad=0.19p pd=1.38u as=0.19p ps=1.38u w=1u l=0.13u
X226 a_1941_6375# a_1839_6967# a_1839_5853.t1 VDD.t6 sg13_lv_pmos ad=0.38p pd=2.38u as=0.38p ps=2.38u w=2u l=0.13u
X227 VSS.t98 Vref.t3 a_1941_10309# VSS.t97 sg13_lv_nmos ad=0.34p pd=2.68u as=0.19p ps=1.38u w=1u l=0.13u
X228 a_917_6931.t0 Vref.t4 VSS.t100 VSS.t99 sg13_lv_nmos ad=0.34p pd=2.68u as=0.34p ps=2.68u w=1u l=0.13u
X229 vCMP.t0 a_4828_5366# VSS.t135 VSS.t134 sg13_lv_nmos ad=0.19p pd=1.38u as=0.34p ps=2.68u w=1u l=0.13u
X230 a_3521_6967# VOUT.t8 sub! rppd l=0.5u w=0.5u
X231 VDD.t18 a_3317_6967# a_3521_6967# VDD.t6 sg13_lv_pmos ad=0.38p pd=2.38u as=0.38p ps=2.38u w=2u l=0.13u
X232 a_3521_9195# a_3317_9195# VDD.t92 VDD.t4 sg13_lv_pmos ad=0.68p pd=4.68u as=0.38p ps=2.38u w=2u l=0.13u
X233 VSS.t203 VSS.t204 sub! rppd l=0.5u w=0.5u
X234 a_3521_5853# a_3317_5853# VSS.t86 VSS.t85 sg13_lv_nmos ad=0.19p pd=1.38u as=0.34p ps=2.68u w=1u l=0.13u
X235 a_3317_9195# a_2907_9195# VDD.t67 VDD.t4 sg13_lv_pmos ad=0.68p pd=4.68u as=0.68p ps=4.68u w=2u l=0.13u
X236 a_2805_8603# a_1839_8081# VDD.t33 VDD.t4 sg13_lv_pmos ad=0.38p pd=2.38u as=0.68p ps=4.68u w=2u l=0.13u
X237 VSS.t90 a_3317_8081# a_3521_8081# VSS.t80 sg13_lv_nmos ad=0.19p pd=1.38u as=0.19p ps=1.38u w=1u l=0.13u
X238 VDD.t12 a_2380_6967# a_3009_6967# VDD.t6 sg13_lv_pmos ad=0.68p pd=4.68u as=0.38p ps=2.38u w=2u l=0.13u
X239 VSS.t21 a_1479_4709# a_1071_4709# VSS.t20 sg13_lv_nmos ad=0.34p pd=2.68u as=0.34p ps=2.68u w=1u l=0.13u
X240 VDD.t102 a_917_6931.t7 a_1941_8603# VDD.t4 sg13_lv_pmos ad=0.68p pd=4.68u as=0.38p ps=2.38u w=2u l=0.13u
X241 a_2584_6967# a_1267_6967# VDD.t45 VDD.t6 sg13_lv_pmos ad=0.68p pd=4.68u as=0.68p ps=4.68u w=2u l=0.13u
X242 VSS.t29 VSS.t30 sub! rppd l=0.5u w=0.5u
X243 a_1941_7689# a_1839_8081# a_1839_6967# VSS.t123 sg13_lv_nmos ad=0.19p pd=1.38u as=0.19p ps=1.38u w=1u l=0.13u
X244 VDD.t40 a_4828_5366# vCMP.t1 VDD.t2 sg13_lv_pmos ad=0.38p pd=2.38u as=0.38p ps=2.38u w=2u l=0.13u
X245 VDD.t17 a_3207_4709# a_2840_5276# VDD.t2 sg13_lv_pmos ad=0.68p pd=4.68u as=0.68p ps=4.68u w=2u l=0.65u
X246 VSS.t239 a_1071_4709# Ven VSS.t238 sg13_lv_nmos ad=0.19p pd=1.38u as=0.34p ps=2.68u w=1u l=0.13u
X247 VSS.t138 VSS.t139 sub! rppd l=0.5u w=0.5u
X248 a_1369_10831# a_1267_5853.t2 a_1267_10309# VDD.t13 sg13_lv_pmos ad=0.38p pd=2.38u as=0.38p ps=2.38u w=2u l=0.13u
X249 VSS.t184 VSS.t185 sub! rppd l=0.5u w=0.5u
X250 VSS.t49 a_2380_8081# a_3009_8081# VSS.t48 sg13_lv_nmos ad=0.34p pd=2.68u as=0.19p ps=1.38u w=1u l=0.13u
X251 a_1369_6375# a_1267_6967# a_1267_5853.t1 VDD.t6 sg13_lv_pmos ad=0.38p pd=2.38u as=0.38p ps=2.38u w=2u l=0.13u
X252 a_2584_8081# a_1267_8081# VSS.t231 VSS.t146 sg13_lv_nmos ad=0.34p pd=2.68u as=0.34p ps=2.68u w=1u l=0.13u
X253 a_917_6931.t2 a_917_6931.t1 VDD.t83 VDD.t6 sg13_lv_pmos ad=0.68p pd=4.68u as=0.68p ps=4.68u w=2u l=0.13u
X254 a_2907_5853# a_2584_5853# a_2805_6375# VDD.t6 sg13_lv_pmos ad=0.38p pd=2.38u as=0.38p ps=2.38u w=2u l=0.13u
X255 VSS.t201 VSS.t202 sub! rppd l=0.5u w=0.5u
X256 a_4828_5366# VOUT.t12 VSS.t137 VSS.t154 sg13_lv_nmos ad=0.19p pd=1.38u as=0.19p ps=1.38u w=1u l=0.13u
X257 a_2805_9917# a_1839_9195# VSS.t244 VSS.t236 sg13_lv_nmos ad=0.19p pd=1.38u as=0.34p ps=2.68u w=1u l=0.13u
X258 a_3521_8081# a_3317_8081# VDD.t24 VDD.t4 sg13_lv_pmos ad=0.38p pd=2.38u as=0.68p ps=4.68u w=2u l=0.13u
X259 a_917_8508.t2 Vctr.t6 VSS.t162 VSS.t99 sg13_lv_nmos ad=0.34p pd=2.68u as=0.34p ps=2.68u w=1u l=0.13u
X260 a_1820_4745# vCMP.t4 VDD.t39 VDD.t2 sg13_lv_pmos ad=0.38p pd=2.38u as=0.38p ps=2.38u w=2u l=0.13u
X261 a_3521_10309# a_3317_10309# VDD.t96 VDD.t13 sg13_lv_pmos ad=0.38p pd=2.38u as=0.68p ps=4.68u w=2u l=0.13u
X262 VSS.t101 Vref.t5 a_1941_9917# VSS.t97 sg13_lv_nmos ad=0.34p pd=2.68u as=0.19p ps=1.38u w=1u l=0.13u
X263 VSS.t102 VSS.t103 sub! rppd l=0.5u w=0.5u
X264 a_2584_10309# a_1267_10309# VDD.t76 VDD.t13 sg13_lv_pmos ad=0.68p pd=4.68u as=0.68p ps=4.68u w=2u l=0.13u
X265 a_1369_7689# a_1267_8081# a_1267_6967# VSS.t166 sg13_lv_nmos ad=0.19p pd=1.38u as=0.19p ps=1.38u w=1u l=0.13u
X266 a_1941_6967# a_1839_8081# a_1839_6967# VDD.t6 sg13_lv_pmos ad=0.38p pd=2.38u as=0.38p ps=2.38u w=2u l=0.13u
X267 a_3521_5853# a_3317_5853# VDD.t21 VDD.t6 sg13_lv_pmos ad=0.68p pd=4.68u as=0.38p ps=2.38u w=2u l=0.13u
X268 a_2769_4709# a_2840_5276# VDD.t10 VDD.t2 sg13_lv_pmos ad=0.38p pd=2.38u as=0.38p ps=2.38u w=2u l=0.13u
X269 VDD.t90 VDD.t91 sub! rhigh l=4u w=0.5u
X270 Vctr.t0 a_1742_11577# sub! rhigh l=4u w=0.5u
X271 VDD.t36 VDD.t37 sub! rhigh l=4u w=0.5u
X272 a_2907_6967# a_1267_6967# a_2805_7689# VSS.t145 sg13_lv_nmos ad=0.19p pd=1.38u as=0.19p ps=1.38u w=1u l=0.13u
X273 VDD.t30 VOUT.t11 a_4828_5366# VDD.t29 sg13_lv_pmos ad=0.68p pd=4.68u as=0.38p ps=2.38u w=2u l=0.13u
X274 a_3317_5853# a_2907_5853# VDD.t35 VDD.t6 sg13_lv_pmos ad=0.68p pd=4.68u as=0.68p ps=4.68u w=2u l=0.13u
X275 a_2805_10831# a_1839_10309# VDD.t103 VDD.t13 sg13_lv_pmos ad=0.38p pd=2.38u as=0.68p ps=4.68u w=2u l=0.13u
X276 VDD.t3 a_1479_4709# a_1071_4709# VDD.t2 sg13_lv_pmos ad=0.68p pd=4.68u as=0.68p ps=4.68u w=2u l=0.13u
X277 a_1839_5853.t0 Ven VSS.t1 VSS.t0 sg13_lv_nmos ad=0.19p pd=1.38u as=0.34p ps=2.68u w=1u l=0.13u
X278 a_3521_8081# VOUT.t5 sub! rppd l=0.5u w=0.5u
X279 a_1941_8081# a_1839_9195# a_1839_8081# VSS.t123 sg13_lv_nmos ad=0.19p pd=1.38u as=0.19p ps=1.38u w=1u l=0.13u
X280 VSS.t170 a_2538_4709# a_2130_4709# VSS.t169 sg13_lv_nmos ad=0.34p pd=2.68u as=0.34p ps=2.68u w=1u l=0.13u
X281 a_3521_9195# a_3317_9195# VSS.t219 VSS.t218 sg13_lv_nmos ad=0.19p pd=1.38u as=0.34p ps=2.68u w=1u l=0.13u
X282 VDD.t105 a_1071_4709# Ven VDD.t2 sg13_lv_pmos ad=0.38p pd=2.38u as=0.68p ps=4.68u w=2u l=0.13u
X283 VSS.t155 VSS.t156 sub! rppd l=0.5u w=0.5u
X284 VSS.t141 a_2130_4709# SPIKE.t0 VSS.t140 sg13_lv_nmos ad=0.19p pd=1.38u as=0.34p ps=2.68u w=1u l=0.13u
X285 VSS.t45 a_2769_4709# a_2538_4709# VSS.t225 sg13_lv_nmos ad=0.19p pd=1.38u as=0.34p ps=2.68u w=1u l=0.13u
R0 VSS.n113 VSS.n25 30510.4
R1 VSS.t238 VSS.n202 7482.41
R2 VSS.n202 VSS.n113 6449.35
R3 VSS.n230 VSS.n25 4691.1
R4 VSS.n230 VSS.t106 3100.04
R5 VSS.n113 VSS.n112 1397.79
R6 VSS.n202 VSS.n201 853.591
R7 VSS.t242 VSS.t238 280.993
R8 VSS.n59 VSS.t8 200.773
R9 VSS.t4 VSS.n128 200.773
R10 VSS.t106 VSS.t154 194.162
R11 VSS.n66 VSS.t234 192.486
R12 VSS.t61 VSS.n124 192.486
R13 VSS.t164 VSS.n48 192.386
R14 VSS.n147 VSS.t146 192.386
R15 VSS.n208 VSS.t20 189.142
R16 VSS.t97 VSS.n50 185.083
R17 VSS.n143 VSS.t149 185.083
R18 VSS.t152 VSS.n211 184.573
R19 VSS.t159 VSS.n52 174.034
R20 VSS.n141 VSS.t166 174.034
R21 VSS.n206 VSS.t148 173.554
R22 VSS.n205 VSS.t240 173.554
R23 VSS.n214 VSS.t144 159.78
R24 VSS.t154 VSS.n229 154.189
R25 VSS.t22 VSS.n46 151.935
R26 VSS.n70 VSS.t236 151.935
R27 VSS.n149 VSS.t186 151.935
R28 VSS.t59 VSS.n120 151.935
R29 VSS.n201 VSS.t99 151.935
R30 VSS.n219 VSS.t33 151.516
R31 VSS.n217 VSS.t206 151.516
R32 VSS.t218 VSS.n44 150.95
R33 VSS.n74 VSS.t157 150.95
R34 VSS.n153 VSS.t82 150.95
R35 VSS.t93 VSS.n118 150.95
R36 VSS.t85 VSS.n221 150.572
R37 VSS.n209 VSS.t243 148.761
R38 VSS.n79 VSS.t222 146.41
R39 VSS.t80 VSS.n115 146.41
R40 VSS.n223 VSS.t89 146.006
R41 VSS.t169 VSS.n215 136.798
R42 VSS.t140 VSS.n212 135.601
R43 VSS.n79 VSS.t220 135.359
R44 VSS.n115 VSS.t84 135.359
R45 VSS.t87 VSS.n223 134.987
R46 VSS.t132 VSS.n209 132.232
R47 VSS.t57 VSS.n46 129.834
R48 VSS.n70 VSS.t163 129.834
R49 VSS.n149 VSS.t48 129.834
R50 VSS.t145 VSS.n120 129.834
R51 VSS.t27 VSS.n219 129.477
R52 VSS.n227 VSS.t130 127.073
R53 VSS.t2 VSS.n134 123.424
R54 VSS.n226 VSS.t190 123.299
R55 VSS.t142 VSS.n214 121.213
R56 VSS.n225 VSS.t25 119.505
R57 VSS.t209 VSS.n52 107.736
R58 VSS.n112 VSS.t6 107.736
R59 VSS.n141 VSS.t181 107.736
R60 VSS.t211 VSS.n206 107.439
R61 VSS.t10 VSS.n203 107.439
R62 VSS.n51 VSS.t208 105.555
R63 VSS.t123 VSS.n142 105.555
R64 VSS.n228 VSS.t134 104.695
R65 VSS.t44 VSS.n217 101.928
R66 VSS.t208 VSS.n50 96.6856
R67 VSS.n143 VSS.t123 96.6856
R68 VSS.n211 VSS.t63 96.4192
R69 VSS.n59 VSS.t209 95.8024
R70 VSS.t181 VSS.n128 95.8024
R71 VSS.n53 VSS.t6 94.5061
R72 VSS.n140 VSS.t2 94.5061
R73 VSS.t136 VSS.n228 89.4675
R74 VSS.t126 VSS.t68 88.1548
R75 VSS.n213 VSS.t140 80.5052
R76 VSS.n207 VSS.t211 79.8903
R77 VSS.n204 VSS.t10 79.8903
R78 VSS.n203 VSS.t242 79.8903
R79 VSS.n74 VSS.t57 73.6022
R80 VSS.t48 VSS.n118 73.6022
R81 VSS.n220 VSS.t27 73.4388
R82 VSS.t163 VSS.n47 72.4066
R83 VSS.n148 VSS.t145 72.4066
R84 VSS.n218 VSS.t112 72.2407
R85 VSS.t220 VSS.n42 68.177
R86 VSS.t84 VSS.n33 68.1562
R87 VSS.t157 VSS.n44 68.0773
R88 VSS.n153 VSS.t93 68.0773
R89 VSS.n224 VSS.t87 68.0135
R90 VSS.n221 VSS.t126 67.9292
R91 VSS.n78 VSS.t218 66.8818
R92 VSS.t82 VSS.n116 66.8818
R93 VSS.n222 VSS.t85 66.7311
R94 VSS.t68 VSS.n220 62.4185
R95 VSS.t222 VSS.n78 55.832
R96 VSS.n116 VSS.t80 55.832
R97 VSS.t89 VSS.n222 55.7118
R98 VSS.t160 VSS.t169 55.0969
R99 VSS.t95 VSS.t142 55.0969
R100 VSS.t243 VSS.n208 54.1541
R101 VSS.t232 VSS.n210 52.957
R102 VSS.t63 VSS.t232 52.3421
R103 VSS.t0 VSS.t132 52.3421
R104 VSS.n134 VSS.t99 51.6035
R105 VSS.t236 VSS.n67 51.5954
R106 VSS.n123 VSS.t59 51.5954
R107 VSS.n47 VSS.t22 50.3072
R108 VSS.t186 VSS.n148 50.3072
R109 VSS.t144 VSS.n213 41.9377
R110 VSS.n229 VSS.t136 39.9751
R111 VSS.t134 VSS.n227 39.9408
R112 VSS.t190 VSS.n225 36.0653
R113 VSS.t25 VSS.n224 35.2758
R114 VSS.t130 VSS.n226 32.2726
R115 VSS.n53 VSS.t159 28.2077
R116 VSS.t166 VSS.n140 28.2077
R117 VSS.t33 VSS.t246 27.5487
R118 VSS.t112 VSS.t44 27.5487
R119 VSS.t206 VSS.t225 27.5487
R120 VSS.n67 VSS.t164 26.7335
R121 VSS.t146 VSS.n123 26.7335
R122 VSS.n216 VSS.t160 26.6999
R123 VSS.t234 VSS.n48 26.6409
R124 VSS.n147 VSS.t61 26.6409
R125 VSS.n215 VSS.t95 26.6068
R126 VSS.t225 VSS.n216 23.9451
R127 VSS.n233 VSS.n16 23.2647
R128 VSS.n234 VSS.n233 22.9546
R129 VSS.t246 VSS.n218 22.654
R130 VSS.n66 VSS.t97 18.4543
R131 VSS.t149 VSS.n124 18.4543
R132 VSS.n233 VSS.n232 18.3543
R133 VSS.t8 VSS.n51 17.158
R134 VSS.n142 VSS.t4 17.158
R135 VSS.n212 VSS.t152 17.1443
R136 VSS.n210 VSS.t0 17.1443
R137 VSS.n232 VSS.n231 17.001
R138 VSS.n112 VSS.n111 17.0005
R139 VSS.n111 VSS.n52 17.0005
R140 VSS.n111 VSS.n50 17.0005
R141 VSS.n111 VSS.n70 17.0005
R142 VSS.n111 VSS.n46 17.0005
R143 VSS.n111 VSS.n45 17.0005
R144 VSS.n111 VSS.n79 17.0005
R145 VSS.n111 VSS.n16 17.0005
R146 VSS.n203 VSS.n0 17.0005
R147 VSS.n204 VSS.n0 17.0005
R148 VSS.n205 VSS.n0 17.0005
R149 VSS.n206 VSS.n0 17.0005
R150 VSS.n207 VSS.n0 17.0005
R151 VSS.n284 VSS.n0 17.0005
R152 VSS.n209 VSS.n0 17.0005
R153 VSS.n211 VSS.n0 17.0005
R154 VSS.n214 VSS.n0 17.0005
R155 VSS.n274 VSS.n0 17.0005
R156 VSS.n270 VSS.n0 17.0005
R157 VSS.n266 VSS.n0 17.0005
R158 VSS.n217 VSS.n0 17.0005
R159 VSS.n219 VSS.n0 17.0005
R160 VSS.n262 VSS.n0 17.0005
R161 VSS.n258 VSS.n0 17.0005
R162 VSS.n254 VSS.n0 17.0005
R163 VSS.n223 VSS.n0 17.0005
R164 VSS.n250 VSS.n0 17.0005
R165 VSS.n242 VSS.n0 17.0005
R166 VSS.n240 VSS.n0 17.0005
R167 VSS.n228 VSS.n0 17.0005
R168 VSS.n236 VSS.n0 17.0005
R169 VSS.n229 VSS.n0 17.0005
R170 VSS.n200 VSS.n135 17.0005
R171 VSS.n201 VSS.n200 17.0005
R172 VSS.n200 VSS.n141 17.0005
R173 VSS.n200 VSS.n143 17.0005
R174 VSS.n200 VSS.n120 17.0005
R175 VSS.n200 VSS.n149 17.0005
R176 VSS.n200 VSS.n152 17.0005
R177 VSS.n200 VSS.n115 17.0005
R178 VSS.n200 VSS.n199 17.0005
R179 VSS.n190 VSS.n189 17.0005
R180 VSS.n189 VSS.n188 17.0005
R181 VSS.n184 VSS.n183 17.0005
R182 VSS.n183 VSS.n182 17.0005
R183 VSS.n60 VSS.t76 15.5174
R184 VSS.n54 VSS.t74 15.5174
R185 VSS.n129 VSS.t72 15.5174
R186 VSS.n137 VSS.t70 15.5174
R187 VSS.n82 VSS.t19 15.3892
R188 VSS.n85 VSS.t109 15.3892
R189 VSS.n1 VSS.t15 15.3892
R190 VSS.n192 VSS.t37 15.3892
R191 VSS.n195 VSS.t174 15.3892
R192 VSS.n37 VSS.t199 15.3864
R193 VSS.n34 VSS.t247 15.3864
R194 VSS.n13 VSS.t214 15.3864
R195 VSS.n20 VSS.t138 15.3864
R196 VSS.n17 VSS.t216 15.3864
R197 VSS.n104 VSS.t117 15.2062
R198 VSS.n107 VSS.t110 15.2062
R199 VSS.n99 VSS.t34 15.2062
R200 VSS.n102 VSS.t197 15.2062
R201 VSS.n94 VSS.t118 15.2062
R202 VSS.n97 VSS.t111 15.2062
R203 VSS.n90 VSS.t35 15.2062
R204 VSS.n93 VSS.t198 15.2062
R205 VSS.n8 VSS.t223 15.2062
R206 VSS.n11 VSS.t50 15.2062
R207 VSS.n4 VSS.t224 15.2062
R208 VSS.n7 VSS.t51 15.2062
R209 VSS.n175 VSS.t167 15.2062
R210 VSS.n178 VSS.t46 15.2062
R211 VSS.n170 VSS.t249 15.2062
R212 VSS.n173 VSS.t104 15.2062
R213 VSS.n162 VSS.t168 15.2062
R214 VSS.n165 VSS.t47 15.2062
R215 VSS.n158 VSS.t250 15.2062
R216 VSS.n161 VSS.t105 15.2062
R217 VSS.n37 VSS.t54 15.0005
R218 VSS.n38 VSS.t175 15.0005
R219 VSS.n39 VSS.t102 15.0005
R220 VSS.n34 VSS.t23 15.0005
R221 VSS.n35 VSS.t119 15.0005
R222 VSS.n36 VSS.t115 15.0005
R223 VSS.n104 VSS.t200 15.0005
R224 VSS.n105 VSS.t55 15.0005
R225 VSS.n106 VSS.t176 15.0005
R226 VSS.n107 VSS.t103 15.0005
R227 VSS.n99 VSS.t248 15.0005
R228 VSS.n100 VSS.t24 15.0005
R229 VSS.n101 VSS.t120 15.0005
R230 VSS.n102 VSS.t116 15.0005
R231 VSS.n94 VSS.t108 15.0005
R232 VSS.n95 VSS.t29 15.0005
R233 VSS.n96 VSS.t31 15.0005
R234 VSS.n97 VSS.t226 15.0005
R235 VSS.n90 VSS.t18 15.0005
R236 VSS.n92 VSS.t42 15.0005
R237 VSS.n91 VSS.t52 15.0005
R238 VSS.n93 VSS.t184 15.0005
R239 VSS.n84 VSS.t185 15.0005
R240 VSS.n83 VSS.t43 15.0005
R241 VSS.n82 VSS.t53 15.0005
R242 VSS.n85 VSS.t30 15.0005
R243 VSS.n86 VSS.t32 15.0005
R244 VSS.n87 VSS.t227 15.0005
R245 VSS.n13 VSS.t64 15.0005
R246 VSS.n14 VSS.t187 15.0005
R247 VSS.n15 VSS.t40 15.0005
R248 VSS.n8 VSS.t215 15.0005
R249 VSS.n9 VSS.t65 15.0005
R250 VSS.n10 VSS.t188 15.0005
R251 VSS.n11 VSS.t41 15.0005
R252 VSS.n4 VSS.t14 15.0005
R253 VSS.n6 VSS.t16 15.0005
R254 VSS.n5 VSS.t201 15.0005
R255 VSS.n7 VSS.t12 15.0005
R256 VSS.n3 VSS.t13 15.0005
R257 VSS.n2 VSS.t17 15.0005
R258 VSS.n1 VSS.t202 15.0005
R259 VSS.n20 VSS.t195 15.0005
R260 VSS.n21 VSS.t177 15.0005
R261 VSS.n22 VSS.t66 15.0005
R262 VSS.n17 VSS.t203 15.0005
R263 VSS.n18 VSS.t78 15.0005
R264 VSS.n19 VSS.t38 15.0005
R265 VSS.n175 VSS.t139 15.0005
R266 VSS.n176 VSS.t196 15.0005
R267 VSS.n177 VSS.t178 15.0005
R268 VSS.n178 VSS.t67 15.0005
R269 VSS.n170 VSS.t217 15.0005
R270 VSS.n171 VSS.t204 15.0005
R271 VSS.n172 VSS.t79 15.0005
R272 VSS.n173 VSS.t39 15.0005
R273 VSS.n162 VSS.t173 15.0005
R274 VSS.n163 VSS.t113 15.0005
R275 VSS.n164 VSS.t193 15.0005
R276 VSS.n165 VSS.t155 15.0005
R277 VSS.n158 VSS.t36 15.0005
R278 VSS.n160 VSS.t121 15.0005
R279 VSS.n159 VSS.t179 15.0005
R280 VSS.n161 VSS.t128 15.0005
R281 VSS.n194 VSS.t129 15.0005
R282 VSS.n193 VSS.t122 15.0005
R283 VSS.n192 VSS.t180 15.0005
R284 VSS.n195 VSS.t114 15.0005
R285 VSS.n196 VSS.t194 15.0005
R286 VSS.n197 VSS.t156 15.0005
R287 VSS.t20 VSS.n207 13.7746
R288 VSS.t148 VSS.n205 13.7746
R289 VSS.t240 VSS.n204 13.7746
R290 VSS.n230 VSS.n33 13.3522
R291 VSS.n230 VSS.n32 8.501
R292 VSS.n230 VSS.n31 8.501
R293 VSS.n230 VSS.n30 8.501
R294 VSS.n230 VSS.n29 8.501
R295 VSS.n230 VSS.n28 8.501
R296 VSS.n230 VSS.n27 8.501
R297 VSS.n230 VSS.n26 8.501
R298 VSS.n231 VSS.n230 8.501
R299 VSS.n291 VSS.n0 8.4798
R300 VSS.n282 VSS.n0 8.4798
R301 VSS.n280 VSS.n0 8.4798
R302 VSS.n278 VSS.n0 8.4798
R303 VSS.n276 VSS.n0 8.4798
R304 VSS.n272 VSS.n0 8.4798
R305 VSS.n268 VSS.n0 8.4798
R306 VSS.n260 VSS.n0 8.4798
R307 VSS.n246 VSS.n0 8.4798
R308 VSS.n238 VSS.n0 8.4798
R309 VSS.n191 VSS.n157 8.4798
R310 VSS.n187 VSS.n167 8.4798
R311 VSS.n186 VSS.n168 8.4798
R312 VSS.n185 VSS.n169 8.4798
R313 VSS.n181 VSS.n24 8.4798
R314 VSS.n265 VSS.t45 6.08585
R315 VSS.n259 VSS.t69 6.08585
R316 VSS.n253 VSS.t205 6.08585
R317 VSS.n249 VSS.t26 6.08585
R318 VSS.n245 VSS.t191 6.08585
R319 VSS.n243 VSS.t131 6.08585
R320 VSS.n80 VSS.t221 6.08241
R321 VSS.n76 VSS.t219 6.08241
R322 VSS.n75 VSS.t158 6.08241
R323 VSS.n72 VSS.t189 6.08241
R324 VSS.n71 VSS.t244 6.08241
R325 VSS.n68 VSS.t165 6.08241
R326 VSS.n64 VSS.t245 6.08241
R327 VSS.n63 VSS.t101 6.08241
R328 VSS.n57 VSS.t213 6.08241
R329 VSS.n293 VSS.t239 6.08241
R330 VSS.n290 VSS.t241 6.08241
R331 VSS.n287 VSS.t21 6.08241
R332 VSS.n285 VSS.t133 6.08241
R333 VSS.n281 VSS.t233 6.08241
R334 VSS.n277 VSS.t141 6.08241
R335 VSS.n273 VSS.t143 6.08241
R336 VSS.n269 VSS.t170 6.08241
R337 VSS.n239 VSS.t135 6.08241
R338 VSS.n235 VSS.t137 6.08241
R339 VSS.n234 VSS.t107 6.08241
R340 VSS.n155 VSS.t81 6.08241
R341 VSS.n154 VSS.t83 6.08241
R342 VSS.n150 VSS.t192 6.08241
R343 VSS.n151 VSS.t56 6.08241
R344 VSS.n121 VSS.t60 6.08241
R345 VSS.n145 VSS.t147 6.08241
R346 VSS.n144 VSS.t62 6.08241
R347 VSS.n126 VSS.t150 6.08241
R348 VSS.n132 VSS.t182 6.08241
R349 VSS.n136 VSS.t100 6.08241
R350 VSS.n80 VSS.t228 6.08198
R351 VSS.n76 VSS.t230 6.08198
R352 VSS.n75 VSS.t171 6.08198
R353 VSS.n72 VSS.t58 6.08198
R354 VSS.n71 VSS.t237 6.08198
R355 VSS.n68 VSS.t172 6.08198
R356 VSS.n64 VSS.t235 6.08198
R357 VSS.n63 VSS.t98 6.08198
R358 VSS.n61 VSS.t9 6.08198
R359 VSS.n57 VSS.t210 6.08198
R360 VSS.n55 VSS.t7 6.08198
R361 VSS.n255 VSS.t88 6.08198
R362 VSS.n257 VSS.t86 6.08198
R363 VSS.n261 VSS.t127 6.08198
R364 VSS.n263 VSS.t28 6.08198
R365 VSS.n267 VSS.t207 6.08198
R366 VSS.n271 VSS.t161 6.08198
R367 VSS.n275 VSS.t96 6.08198
R368 VSS.n279 VSS.t153 6.08198
R369 VSS.n283 VSS.t1 6.08198
R370 VSS.n288 VSS.t212 6.08198
R371 VSS.n292 VSS.t11 6.08198
R372 VSS.n155 VSS.t90 6.08198
R373 VSS.n154 VSS.t91 6.08198
R374 VSS.n150 VSS.t94 6.08198
R375 VSS.n151 VSS.t49 6.08198
R376 VSS.n121 VSS.t124 6.08198
R377 VSS.n145 VSS.t231 6.08198
R378 VSS.n144 VSS.t125 6.08198
R379 VSS.n126 VSS.t151 6.08198
R380 VSS.n130 VSS.t5 6.08198
R381 VSS.n132 VSS.t183 6.08198
R382 VSS.n138 VSS.t3 6.08198
R383 VSS.n136 VSS.t162 6.08198
R384 VSS.n111 VSS.n49 5.6302
R385 VSS.n111 VSS.n69 5.6302
R386 VSS.n111 VSS.n77 5.6302
R387 VSS.n111 VSS.n43 5.6302
R388 VSS.n111 VSS.n41 5.6302
R389 VSS.n289 VSS.n0 5.6302
R390 VSS.n286 VSS.n0 5.6302
R391 VSS.n256 VSS.n0 5.6302
R392 VSS.n248 VSS.n0 5.6302
R393 VSS.n200 VSS.n146 5.6302
R394 VSS.n200 VSS.n122 5.6302
R395 VSS.n200 VSS.n117 5.6302
R396 VSS.n200 VSS.n156 5.6302
R397 VSS.n60 VSS.t77 5.56245
R398 VSS.n54 VSS.t75 5.56245
R399 VSS.n129 VSS.t73 5.56245
R400 VSS.n137 VSS.t71 5.56245
R401 VSS.n111 VSS.n58 4.19857
R402 VSS.n111 VSS.n62 4.19857
R403 VSS.n111 VSS.n65 4.19857
R404 VSS.n111 VSS.n89 4.19857
R405 VSS.n252 VSS.n0 4.19857
R406 VSS.n200 VSS.n139 4.19857
R407 VSS.n200 VSS.n131 4.19857
R408 VSS.n200 VSS.n127 4.19857
R409 VSS.n200 VSS.n125 4.19857
R410 VSS.n111 VSS.n56 3.33426
R411 VSS.n111 VSS.n81 3.33426
R412 VSS.n264 VSS.n0 3.33426
R413 VSS.n244 VSS.n0 3.33426
R414 VSS.n200 VSS.n133 3.33426
R415 VSS.n200 VSS.n114 3.33426
R416 VSS.n111 VSS.n73 2.75376
R417 VSS.n200 VSS.n119 2.75376
R418 VSS.n111 VSS.n110 2.01901
R419 VSS.n210 VSS.n0 1.30676
R420 VSS.n212 VSS.n0 1.30676
R421 VSS.n213 VSS.n0 1.30676
R422 VSS.n218 VSS.n0 1.30676
R423 VSS.n222 VSS.n0 1.30676
R424 VSS.n111 VSS.n53 1.30371
R425 VSS.n111 VSS.n51 1.30371
R426 VSS.n111 VSS.n47 1.30371
R427 VSS.n111 VSS.n78 1.30371
R428 VSS.n200 VSS.n140 1.30371
R429 VSS.n200 VSS.n142 1.30371
R430 VSS.n200 VSS.n148 1.30371
R431 VSS.n200 VSS.n116 1.30371
R432 VSS.n42 VSS.n25 0.983685
R433 VSS.n61 VSS.n60 0.520462
R434 VSS.n55 VSS.n54 0.520462
R435 VSS.n130 VSS.n129 0.520462
R436 VSS.n138 VSS.n137 0.520462
R437 VSS.n96 VSS.n95 0.394667
R438 VSS.n92 VSS.n91 0.394667
R439 VSS.n83 VSS.n82 0.394667
R440 VSS.n86 VSS.n85 0.394667
R441 VSS.n6 VSS.n5 0.394667
R442 VSS.n2 VSS.n1 0.394667
R443 VSS.n164 VSS.n163 0.394667
R444 VSS.n160 VSS.n159 0.394667
R445 VSS.n193 VSS.n192 0.394667
R446 VSS.n196 VSS.n195 0.394667
R447 VSS.n38 VSS.n37 0.391902
R448 VSS.n35 VSS.n34 0.391902
R449 VSS.n106 VSS.n105 0.391902
R450 VSS.n101 VSS.n100 0.391902
R451 VSS.n14 VSS.n13 0.391902
R452 VSS.n10 VSS.n9 0.391902
R453 VSS.n21 VSS.n20 0.391902
R454 VSS.n18 VSS.n17 0.391902
R455 VSS.n177 VSS.n176 0.391902
R456 VSS.n172 VSS.n171 0.391902
R457 VSS.n84 VSS.n83 0.389167
R458 VSS.n87 VSS.n86 0.389167
R459 VSS.n3 VSS.n2 0.389167
R460 VSS.n194 VSS.n193 0.389167
R461 VSS.n197 VSS.n196 0.389167
R462 VSS.n39 VSS.n38 0.386402
R463 VSS.n36 VSS.n35 0.386402
R464 VSS.n15 VSS.n14 0.386402
R465 VSS.n22 VSS.n21 0.386402
R466 VSS.n19 VSS.n18 0.386402
R467 VSS.n110 VSS.n98 0.376632
R468 VSS.n88 VSS.n84 0.361667
R469 VSS.n88 VSS.n87 0.361667
R470 VSS.n251 VSS.n3 0.361667
R471 VSS.n198 VSS.n194 0.361667
R472 VSS.n198 VSS.n197 0.361667
R473 VSS.n40 VSS.n39 0.360284
R474 VSS.n40 VSS.n36 0.360284
R475 VSS.n237 VSS.n15 0.360284
R476 VSS.n23 VSS.n22 0.360284
R477 VSS.n23 VSS.n19 0.360284
R478 VSS.n110 VSS.n109 0.310149
R479 VSS.n97 VSS.n96 0.304833
R480 VSS.n95 VSS.n94 0.304833
R481 VSS.n91 VSS.n90 0.304833
R482 VSS.n93 VSS.n92 0.304833
R483 VSS.n5 VSS.n4 0.304833
R484 VSS.n7 VSS.n6 0.304833
R485 VSS.n165 VSS.n164 0.304833
R486 VSS.n163 VSS.n162 0.304833
R487 VSS.n159 VSS.n158 0.304833
R488 VSS.n161 VSS.n160 0.304833
R489 VSS.n105 VSS.n104 0.304646
R490 VSS.n100 VSS.n99 0.304646
R491 VSS.n9 VSS.n8 0.304646
R492 VSS.n176 VSS.n175 0.304646
R493 VSS.n171 VSS.n170 0.304646
R494 VSS.n108 VSS.n106 0.303451
R495 VSS.n103 VSS.n101 0.303451
R496 VSS.n12 VSS.n10 0.303451
R497 VSS.n179 VSS.n177 0.303451
R498 VSS.n174 VSS.n172 0.303451
R499 VSS.n109 VSS.n103 0.277333
R500 VSS.n109 VSS.n108 0.277333
R501 VSS.n98 VSS.n93 0.277333
R502 VSS.n98 VSS.n97 0.277333
R503 VSS.n241 VSS.n12 0.277333
R504 VSS.n247 VSS.n7 0.277333
R505 VSS.n180 VSS.n174 0.277333
R506 VSS.n180 VSS.n179 0.277333
R507 VSS.n166 VSS.n161 0.277333
R508 VSS.n166 VSS.n165 0.277333
R509 VSS.n73 VSS.n71 0.260169
R510 VSS.n121 VSS.n119 0.260169
R511 VSS.n235 VSS.n234 0.2555
R512 VSS.n73 VSS.n72 0.248456
R513 VSS.n151 VSS.n119 0.248456
R514 VSS.n88 VSS.n81 0.247269
R515 VSS.n198 VSS.n114 0.247269
R516 VSS.n244 VSS.n243 0.224769
R517 VSS.n139 VSS.n136 0.208819
R518 VSS.n264 VSS.n263 0.207269
R519 VSS.n252 VSS.n251 0.205556
R520 VSS.n245 VSS.n244 0.198496
R521 VSS.n139 VSS.n138 0.198056
R522 VSS.n57 VSS.n56 0.197269
R523 VSS.n133 VSS.n132 0.197269
R524 VSS.n62 VSS.n61 0.193819
R525 VSS.n130 VSS.n127 0.193819
R526 VSS.n63 VSS.n62 0.190556
R527 VSS.n127 VSS.n126 0.190556
R528 VSS.n265 VSS.n264 0.188496
R529 VSS.n58 VSS.n57 0.186319
R530 VSS.n132 VSS.n131 0.186319
R531 VSS.n56 VSS.n55 0.185996
R532 VSS.n138 VSS.n133 0.185996
R533 VSS.n81 VSS.n80 0.173496
R534 VSS.n155 VSS.n114 0.173496
R535 VSS.n186 VSS.n185 0.171288
R536 VSS.n187 VSS.n186 0.171288
R537 VSS.n80 VSS.n43 0.168406
R538 VSS.n77 VSS.n76 0.168406
R539 VSS.n256 VSS.n255 0.168406
R540 VSS.n156 VSS.n155 0.168406
R541 VSS.n154 VSS.n117 0.168406
R542 VSS.n286 VSS.n285 0.167156
R543 VSS.n69 VSS.n68 0.154994
R544 VSS.n64 VSS.n49 0.154994
R545 VSS.n145 VSS.n122 0.154994
R546 VSS.n146 VSS.n144 0.154994
R547 VSS.n109 VSS.n41 0.152494
R548 VSS.n65 VSS.n63 0.151319
R549 VSS.n253 VSS.n252 0.151319
R550 VSS.n126 VSS.n125 0.151319
R551 VSS.n61 VSS.n58 0.148056
R552 VSS.n131 VSS.n130 0.148056
R553 VSS.n65 VSS.n64 0.144306
R554 VSS.n144 VSS.n125 0.144306
R555 VSS.n89 VSS.n88 0.136319
R556 VSS.n98 VSS.n89 0.130556
R557 VSS.n182 VSS.n181 0.128394
R558 VSS.n185 VSS.n184 0.128394
R559 VSS.n188 VSS.n187 0.128394
R560 VSS.n191 VSS.n190 0.128394
R561 VSS.n199 VSS.n191 0.128394
R562 VSS.n247 VSS.n246 0.125894
R563 VSS.n282 VSS.n281 0.124644
R564 VSS.n71 VSS.n69 0.123406
R565 VSS.n122 VSS.n121 0.123406
R566 VSS.n55 VSS 0.11675
R567 VSS.n41 VSS.n40 0.114656
R568 VSS.n289 VSS.n288 0.113406
R569 VSS.n291 VSS.n290 0.113394
R570 VSS.n249 VSS.n248 0.111244
R571 VSS.n260 VSS.n259 0.108394
R572 VSS.n283 VSS.n282 0.108394
R573 VSS.n280 VSS.n279 0.105894
R574 VSS.n68 VSS.n49 0.102156
R575 VSS.n146 VSS.n145 0.102156
R576 VSS.n208 VSS.n0 0.101927
R577 VSS.n215 VSS.n0 0.101927
R578 VSS.n220 VSS.n0 0.101927
R579 VSS.n221 VSS.n0 0.101927
R580 VSS.n111 VSS.n48 0.101454
R581 VSS.n111 VSS.n74 0.101454
R582 VSS.n111 VSS.n44 0.101454
R583 VSS.n200 VSS.n147 0.101454
R584 VSS.n200 VSS.n118 0.101454
R585 VSS.n200 VSS.n153 0.101454
R586 VSS.n287 VSS.n286 0.101244
R587 VSS.n290 VSS.n289 0.101244
R588 VSS.n246 VSS.n245 0.100894
R589 VSS.n269 VSS.n268 0.094644
R590 VSS.n273 VSS.n272 0.094644
R591 VSS.n277 VSS.n276 0.094644
R592 VSS.n239 VSS.n238 0.090894
R593 VSS.n76 VSS.n43 0.0887435
R594 VSS.n77 VSS.n75 0.0887435
R595 VSS.n257 VSS.n256 0.0887435
R596 VSS.n156 VSS.n154 0.0887435
R597 VSS.n150 VSS.n117 0.0887435
R598 VSS.n248 VSS.n247 0.0884057
R599 VSS.n293 VSS.n292 0.0855
R600 VSS.n75 VSS.n45 0.083
R601 VSS.n258 VSS.n257 0.083
R602 VSS.n262 VSS.n261 0.083
R603 VSS.n188 VSS.n166 0.083
R604 VSS.n152 VSS.n150 0.083
R605 VSS.n268 VSS.n267 0.080894
R606 VSS.n278 VSS.n277 0.077144
R607 VSS.n238 VSS.n237 0.072144
R608 VSS.n181 VSS.n23 0.072144
R609 VSS.n271 VSS.n270 0.06925
R610 VSS.n275 VSS.n274 0.06925
R611 VSS.n266 VSS.n265 0.068
R612 VSS.n241 VSS.n240 0.06675
R613 VSS.n182 VSS.n180 0.06675
R614 VSS.n279 VSS.n278 0.065894
R615 VSS.n254 VSS.n253 0.063
R616 VSS.n135 VSS 0.063
R617 VSS.n250 VSS.n249 0.0605
R618 VSS.n272 VSS.n271 0.059644
R619 VSS.n276 VSS.n275 0.059644
R620 VSS.n292 VSS.n291 0.058394
R621 VSS.n40 VSS.n16 0.05675
R622 VSS.n237 VSS.n236 0.05675
R623 VSS.n232 VSS.n23 0.05675
R624 VSS.n72 VSS.n45 0.048
R625 VSS.n263 VSS.n262 0.048
R626 VSS.n267 VSS.n266 0.048
R627 VSS.n152 VSS.n151 0.048
R628 VSS.n281 VSS.n280 0.047144
R629 VSS.n261 VSS.n260 0.045894
R630 VSS.n288 VSS.n287 0.043
R631 VSS.n236 VSS.n235 0.038
R632 VSS.n240 VSS.n239 0.038
R633 VSS.n270 VSS.n269 0.03425
R634 VSS.n274 VSS.n273 0.03425
R635 VSS VSS.n293 0.033
R636 VSS.n243 VSS.n242 0.0305
R637 VSS.n200 VSS.n33 0.022443
R638 VSS.n227 VSS.n0 0.0206285
R639 VSS.n259 VSS.n258 0.0205
R640 VSS.n284 VSS.n283 0.0205
R641 VSS.n242 VSS.n241 0.01925
R642 VSS.n184 VSS.n180 0.01925
R643 VSS.n224 VSS.n0 0.0185172
R644 VSS.n216 VSS.n0 0.00880137
R645 VSS.n111 VSS.n67 0.00874649
R646 VSS.n200 VSS.n123 0.00874649
R647 VSS.n251 VSS.n250 0.008
R648 VSS.n199 VSS.n198 0.008
R649 VSS.n136 VSS.n135 0.0055
R650 VSS.n285 VSS.n284 0.00425
R651 VSS.n225 VSS.n0 0.0031354
R652 VSS.n226 VSS.n0 0.0031354
R653 VSS.n255 VSS.n254 0.003
R654 VSS.n190 VSS.n166 0.003
R655 VSS.n111 VSS.n42 0.002615
R656 VSS.n108 VSS.n107 0.00169565
R657 VSS.n103 VSS.n102 0.00169565
R658 VSS.n12 VSS.n11 0.00169565
R659 VSS.n179 VSS.n178 0.00169565
R660 VSS.n174 VSS.n173 0.00169565
R661 VSS.n111 VSS.n59 0.00163568
R662 VSS.n111 VSS.n66 0.00163568
R663 VSS.n200 VSS.n134 0.00163568
R664 VSS.n200 VSS.n128 0.00163568
R665 VSS.n200 VSS.n124 0.00163568
R666 VSS.n26 VSS.n24 0.001
R667 VSS.n183 VSS.n27 0.001
R668 VSS.n169 VSS.n28 0.001
R669 VSS.n168 VSS.n29 0.001
R670 VSS.n167 VSS.n30 0.001
R671 VSS.n189 VSS.n31 0.001
R672 VSS.n157 VSS.n32 0.001
R673 VSS.n200 VSS.n32 0.001
R674 VSS.n157 VSS.n31 0.001
R675 VSS.n189 VSS.n30 0.001
R676 VSS.n167 VSS.n29 0.001
R677 VSS.n168 VSS.n28 0.001
R678 VSS.n169 VSS.n27 0.001
R679 VSS.n183 VSS.n26 0.001
R680 VSS.n231 VSS.n24 0.001
R681 VDD.n69 VDD.t31 24.9675
R682 VDD.n84 VDD.t91 24.9513
R683 VDD.n75 VDD.t79 24.0041
R684 VDD.n76 VDD.t78 24.0029
R685 VDD.n83 VDD.t90 24.0017
R686 VDD.n100 VDD.t80 24.0017
R687 VDD.n74 VDD.t32 24.0017
R688 VDD.n99 VDD.t77 24.0005
R689 VDD.n146 VDD.n117 23.1572
R690 VDD.n178 VDD.n177 22.9005
R691 VDD.n146 VDD.n145 18.9298
R692 VDD.n177 VDD.n176 18.9261
R693 VDD.n180 VDD.n179 17.0017
R694 VDD.n175 VDD.n153 17.0005
R695 VDD.n175 VDD.n149 17.0005
R696 VDD.n116 VDD.n49 17.0005
R697 VDD.n116 VDD.n48 17.0005
R698 VDD.n116 VDD.n47 17.0005
R699 VDD.n116 VDD.n45 17.0005
R700 VDD.n116 VDD.n43 17.0005
R701 VDD.n144 VDD.n120 17.0005
R702 VDD.n182 VDD.n8 17.0005
R703 VDD.n182 VDD.n32 17.0005
R704 VDD.n182 VDD.n2 17.0005
R705 VDD.n183 VDD.n182 17.0005
R706 VDD.n160 VDD.t49 15.8663
R707 VDD.n154 VDD.t47 15.8663
R708 VDD.n129 VDD.t59 15.8393
R709 VDD.n122 VDD.t57 15.8393
R710 VDD.n50 VDD.t55 15.8387
R711 VDD.n88 VDD.t61 15.8387
R712 VDD.n161 VDD.t53 15.8385
R713 VDD.n155 VDD.t51 15.8385
R714 VDD.n130 VDD.t65 15.8385
R715 VDD.n123 VDD.t63 15.8385
R716 VDD.n91 VDD.t36 15.0343
R717 VDD.n94 VDD.t1 15.0343
R718 VDD.n79 VDD.t0 15.0343
R719 VDD.n72 VDD.t9 15.0343
R720 VDD.n107 VDD.t8 15.0343
R721 VDD.n110 VDD.t71 15.0343
R722 VDD.n70 VDD.t70 15.0343
R723 VDD.n82 VDD.t37 15.0343
R724 VDD.n86 VDD.n84 10.2748
R725 VDD.n98 VDD.n97 10.2748
R726 VDD.n104 VDD.n101 10.2514
R727 VDD.n113 VDD.n69 10.2514
R728 VDD.n112 VDD.n70 9.98894
R729 VDD.n87 VDD.n82 9.9883
R730 VDD.n113 VDD.n112 9.0005
R731 VDD.n111 VDD.n110 9.0005
R732 VDD.n108 VDD.n107 9.0005
R733 VDD.n105 VDD.n104 9.0005
R734 VDD.n73 VDD.n72 9.0005
R735 VDD.n80 VDD.n79 9.0005
R736 VDD.n97 VDD.n96 9.0005
R737 VDD.n95 VDD.n94 9.0005
R738 VDD.n92 VDD.n91 9.0005
R739 VDD.n87 VDD.n86 9.0005
R740 VDD.n116 VDD.n56 8.4798
R741 VDD.n116 VDD.n57 8.4798
R742 VDD.n116 VDD.n46 8.4798
R743 VDD.n116 VDD.n44 8.4798
R744 VDD.n116 VDD.n39 8.4798
R745 VDD.n117 VDD.n116 8.4798
R746 VDD.n182 VDD.n10 8.4798
R747 VDD.n182 VDD.n27 8.4798
R748 VDD.n182 VDD.n4 8.4798
R749 VDD.n182 VDD.n31 8.4798
R750 VDD.n175 VDD.n150 5.6302
R751 VDD.n175 VDD.n168 5.6302
R752 VDD.n175 VDD.n174 5.6302
R753 VDD.n175 VDD.n148 5.6302
R754 VDD.n116 VDD.n53 5.6302
R755 VDD.n116 VDD.n63 5.6302
R756 VDD.n116 VDD.n65 5.6302
R757 VDD.n116 VDD.n67 5.6302
R758 VDD.n116 VDD.n42 5.6302
R759 VDD.n144 VDD.n121 5.6302
R760 VDD.n144 VDD.n137 5.6302
R761 VDD.n144 VDD.n143 5.6302
R762 VDD.n144 VDD.n119 5.6302
R763 VDD.n180 VDD.n37 5.6302
R764 VDD.n180 VDD.n35 5.6302
R765 VDD.n182 VDD.n13 5.6302
R766 VDD.n182 VDD.n9 5.6302
R767 VDD.n182 VDD.n16 5.6302
R768 VDD.n182 VDD.n7 5.6302
R769 VDD.n182 VDD.n20 5.6302
R770 VDD.n182 VDD.n6 5.6302
R771 VDD.n182 VDD.n25 5.6302
R772 VDD.n182 VDD.n5 5.6302
R773 VDD.n182 VDD.n29 5.6302
R774 VDD.n182 VDD.n3 5.6302
R775 VDD.n177 VDD.n146 4.89545
R776 VDD.n175 VDD.n151 4.19857
R777 VDD.n175 VDD.n159 4.19857
R778 VDD.n175 VDD.n163 4.19857
R779 VDD.n175 VDD.n166 4.19857
R780 VDD.n116 VDD.n55 4.19857
R781 VDD.n116 VDD.n40 4.19857
R782 VDD.n144 VDD.n128 4.19857
R783 VDD.n144 VDD.n132 4.19857
R784 VDD.n144 VDD.n135 4.19857
R785 VDD.n182 VDD.n34 4.19857
R786 VDD.n182 VDD.n23 4.19811
R787 VDD.n116 VDD.n60 4.19535
R788 VDD.n36 VDD.t40 3.5161
R789 VDD.n179 VDD.t30 3.51501
R790 VDD.n0 VDD.t41 3.51501
R791 VDD.n22 VDD.t10 3.48173
R792 VDD.n17 VDD.t43 3.48173
R793 VDD.n15 VDD.t39 3.48173
R794 VDD.n11 VDD.t105 3.48173
R795 VDD.n1 VDD.t38 3.48063
R796 VDD.n33 VDD.t84 3.48063
R797 VDD.n30 VDD.t5 3.48063
R798 VDD.n28 VDD.t88 3.48063
R799 VDD.n26 VDD.t17 3.48063
R800 VDD.n24 VDD.t111 3.48063
R801 VDD.n21 VDD.t73 3.48063
R802 VDD.n19 VDD.t42 3.48063
R803 VDD.n14 VDD.t3 3.48063
R804 VDD.n12 VDD.t106 3.48063
R805 VDD.n147 VDD.t21 3.46158
R806 VDD.n54 VDD.t113 3.46158
R807 VDD.n58 VDD.t101 3.46158
R808 VDD.n59 VDD.t104 3.46158
R809 VDD.n61 VDD.t76 3.46158
R810 VDD.n62 VDD.t103 3.46158
R811 VDD.n64 VDD.t14 3.46158
R812 VDD.n66 VDD.t75 3.46158
R813 VDD.n102 VDD.t96 3.46158
R814 VDD.n41 VDD.t97 3.46158
R815 VDD.n118 VDD.t25 3.46158
R816 VDD.n147 VDD.t18 3.4611
R817 VDD.n118 VDD.t92 3.4611
R818 VDD.n173 VDD.t23 3.46092
R819 VDD.n172 VDD.t35 3.46092
R820 VDD.n170 VDD.t7 3.46092
R821 VDD.n169 VDD.t89 3.46092
R822 VDD.n167 VDD.t68 3.46092
R823 VDD.n165 VDD.t28 3.46092
R824 VDD.n164 VDD.t87 3.46092
R825 VDD.n158 VDD.t112 3.46092
R826 VDD.n142 VDD.t24 3.46092
R827 VDD.n141 VDD.t27 3.46092
R828 VDD.n139 VDD.t11 3.46092
R829 VDD.n138 VDD.t33 3.46092
R830 VDD.n136 VDD.t99 3.46092
R831 VDD.n134 VDD.t34 3.46092
R832 VDD.n133 VDD.t102 3.46092
R833 VDD.n127 VDD.t81 3.46092
R834 VDD.n124 VDD.t69 3.46092
R835 VDD.n173 VDD.t19 3.46001
R836 VDD.n172 VDD.t85 3.46001
R837 VDD.n170 VDD.t12 3.46001
R838 VDD.n169 VDD.t15 3.46001
R839 VDD.n167 VDD.t45 3.46001
R840 VDD.n165 VDD.t16 3.46001
R841 VDD.n164 VDD.t100 3.46001
R842 VDD.n158 VDD.t114 3.46001
R843 VDD.n152 VDD.t83 3.46001
R844 VDD.n142 VDD.t94 3.46001
R845 VDD.n141 VDD.t67 3.46001
R846 VDD.n139 VDD.t82 3.46001
R847 VDD.n138 VDD.t109 3.46001
R848 VDD.n136 VDD.t72 3.46001
R849 VDD.n134 VDD.t110 3.46001
R850 VDD.n133 VDD.t86 3.46001
R851 VDD.n127 VDD.t74 3.46001
R852 VDD.n175 VDD.n157 3.33426
R853 VDD.n116 VDD.n52 3.33426
R854 VDD.n144 VDD.n126 3.33426
R855 VDD.n182 VDD.n18 3.32295
R856 VDD.n175 VDD.n171 2.75376
R857 VDD.n116 VDD.n115 2.75376
R858 VDD.n144 VDD.n140 2.75376
R859 VDD.n160 VDD.t50 2.61969
R860 VDD.n161 VDD.t54 2.61969
R861 VDD.n154 VDD.t48 2.61969
R862 VDD.n155 VDD.t52 2.61969
R863 VDD.n129 VDD.t60 2.61969
R864 VDD.n130 VDD.t66 2.61969
R865 VDD.n122 VDD.t58 2.61969
R866 VDD.n123 VDD.t64 2.61969
R867 VDD.n50 VDD.t56 2.61953
R868 VDD.n88 VDD.t62 2.61953
R869 VDD.n181 VDD.n180 2.42957
R870 VDD.n116 VDD.n68 2.33558
R871 VDD.n112 VDD.n111 1.02634
R872 VDD.n92 VDD.n87 1.0235
R873 VDD.n105 VDD.n73 1.02194
R874 VDD.n96 VDD.n80 1.0169
R875 VDD.n84 VDD.n83 1.00928
R876 VDD.n99 VDD.n98 1.00284
R877 VDD.n74 VDD.n69 0.99211
R878 VDD.n108 VDD.n105 0.991144
R879 VDD.n101 VDD.n100 0.989963
R880 VDD.n96 VDD.n95 0.9861
R881 VDD.n101 VDD.n75 0.977085
R882 VDD.n98 VDD.n76 0.959915
R883 VDD.n162 VDD.n161 0.842724
R884 VDD.n156 VDD.n155 0.842724
R885 VDD.n131 VDD.n130 0.842724
R886 VDD.n125 VDD.n123 0.842724
R887 VDD.n51 VDD.n50 0.842552
R888 VDD.n89 VDD.n88 0.842552
R889 VDD.n162 VDD.n160 0.841986
R890 VDD.n156 VDD.n154 0.841986
R891 VDD.n131 VDD.n129 0.841986
R892 VDD.n125 VDD.n122 0.841986
R893 VDD.n176 VDD.n147 0.732983
R894 VDD.n145 VDD.n118 0.732983
R895 VDD.n176 VDD.n175 0.577649
R896 VDD.n145 VDD.n144 0.577649
R897 VDD.n125 VDD.n124 0.4055
R898 VDD.n109 VDD.n68 0.323744
R899 VDD.n182 VDD.t2 0.309591
R900 VDD.n144 VDD.t4 0.298746
R901 VDD.n95 VDD.n92 0.2931
R902 VDD.n115 VDD.n114 0.292669
R903 VDD.n80 VDD.n73 0.2909
R904 VDD.n111 VDD.n108 0.2843
R905 VDD.n100 VDD.n99 0.281671
R906 VDD.n75 VDD.n74 0.279524
R907 VDD.n104 VDD.n103 0.278
R908 VDD.n114 VDD.n113 0.278
R909 VDD.n83 VDD.n76 0.277378
R910 VDD.n175 VDD.t6 0.274694
R911 VDD.n116 VDD.t13 0.274694
R912 VDD.n82 VDD.n81 0.267462
R913 VDD.n91 VDD.n90 0.262498
R914 VDD.n94 VDD.n93 0.262498
R915 VDD.n79 VDD.n78 0.262498
R916 VDD.n72 VDD.n71 0.262498
R917 VDD.n107 VDD.n106 0.262498
R918 VDD.n110 VDD.n109 0.262498
R919 VDD.n70 VDD.n38 0.262498
R920 VDD.n115 VDD.n38 0.262206
R921 VDD.n18 VDD.n17 0.260604
R922 VDD.n171 VDD.n169 0.260169
R923 VDD.n140 VDD.n138 0.260169
R924 VDD.n114 VDD.n68 0.256527
R925 VDD.n86 VDD.n85 0.251389
R926 VDD.n97 VDD.n77 0.251389
R927 VDD.n171 VDD.n170 0.248456
R928 VDD.n140 VDD.n139 0.248456
R929 VDD.n81 VDD.n52 0.232246
R930 VDD.n18 VDD 0.229811
R931 VDD.n152 VDD.n151 0.208819
R932 VDD.n156 VDD.n151 0.198056
R933 VDD.n158 VDD.n157 0.197269
R934 VDD.n127 VDD.n126 0.197269
R935 VDD.n163 VDD.n162 0.193819
R936 VDD.n132 VDD.n131 0.193819
R937 VDD.n164 VDD.n163 0.190556
R938 VDD.n133 VDD.n132 0.190556
R939 VDD.n159 VDD.n158 0.186319
R940 VDD.n128 VDD.n127 0.186319
R941 VDD.n157 VDD.n156 0.185996
R942 VDD.n126 VDD.n125 0.185996
R943 VDD.n52 VDD.n51 0.172269
R944 VDD.n30 VDD.n3 0.169994
R945 VDD.n37 VDD.n36 0.169656
R946 VDD.n55 VDD.n54 0.168819
R947 VDD.n148 VDD.n147 0.168406
R948 VDD.n174 VDD.n173 0.168406
R949 VDD.n42 VDD.n41 0.168406
R950 VDD.n119 VDD.n118 0.168406
R951 VDD.n143 VDD.n142 0.168406
R952 VDD.n29 VDD.n28 0.167494
R953 VDD.n89 VDD.n55 0.165556
R954 VDD.n26 VDD.n5 0.164994
R955 VDD.n34 VDD 0.164306
R956 VDD.n25 VDD.n24 0.162494
R957 VDD.n16 VDD.n15 0.159656
R958 VDD.n60 VDD.n59 0.157247
R959 VDD.n168 VDD.n167 0.154994
R960 VDD.n165 VDD.n150 0.154994
R961 VDD.n63 VDD.n61 0.154994
R962 VDD.n137 VDD.n136 0.154994
R963 VDD.n134 VDD.n121 0.154994
R964 VDD.n23 VDD.n21 0.153169
R965 VDD.n166 VDD.n164 0.151319
R966 VDD.n135 VDD.n133 0.151319
R967 VDD.n21 VDD.n20 0.148406
R968 VDD.n19 VDD.n7 0.148406
R969 VDD.n14 VDD.n9 0.148406
R970 VDD.n13 VDD.n12 0.148406
R971 VDD.n162 VDD.n159 0.148056
R972 VDD.n106 VDD.n40 0.148056
R973 VDD.n131 VDD.n128 0.148056
R974 VDD.n166 VDD.n165 0.144306
R975 VDD.n135 VDD.n134 0.144306
R976 VDD.n103 VDD.n67 0.142156
R977 VDD.n60 VDD.n58 0.138105
R978 VDD.n23 VDD.n22 0.137419
R979 VDD VDD.n25 0.132156
R980 VDD.n41 VDD.n40 0.131319
R981 VDD.n54 VDD.n53 0.130906
R982 VDD.n34 VDD.n33 0.130069
R983 VDD.n5 VDD 0.129656
R984 VDD VDD.n29 0.127156
R985 VDD VDD.n3 0.124656
R986 VDD.n169 VDD.n168 0.123406
R987 VDD.n65 VDD.n64 0.123406
R988 VDD.n63 VDD.n62 0.123406
R989 VDD.n138 VDD.n137 0.123406
R990 VDD.n58 VDD.n57 0.123394
R991 VDD.n77 VDD.n46 0.120894
R992 VDD.n124 VDD 0.1155
R993 VDD VDD.n183 0.113
R994 VDD.n71 VDD.n44 0.110894
R995 VDD.n20 VDD.n19 0.108744
R996 VDD.n17 VDD.n7 0.108744
R997 VDD.n16 VDD.n14 0.108744
R998 VDD.n12 VDD.n9 0.108744
R999 VDD.n13 VDD.n11 0.108744
R1000 VDD.n106 VDD.n39 0.108394
R1001 VDD.n11 VDD.n10 0.105894
R1002 VDD.n71 VDD.n65 0.103744
R1003 VDD.n167 VDD.n150 0.102156
R1004 VDD.n136 VDD.n121 0.102156
R1005 VDD VDD.n6 0.0999935
R1006 VDD.n93 VDD.n56 0.099644
R1007 VDD.n24 VDD.n6 0.0946557
R1008 VDD.n85 VDD.n53 0.0937435
R1009 VDD.n173 VDD.n148 0.0887435
R1010 VDD.n174 VDD.n172 0.0887435
R1011 VDD.n102 VDD.n42 0.0887435
R1012 VDD.n67 VDD.n66 0.0887435
R1013 VDD.n142 VDD.n119 0.0887435
R1014 VDD.n143 VDD.n141 0.0887435
R1015 VDD.n178 VDD.n35 0.0884057
R1016 VDD.n36 VDD.n35 0.0874935
R1017 VDD.n37 VDD.n0 0.0874935
R1018 VDD.n31 VDD 0.087144
R1019 VDD VDD.n4 0.084644
R1020 VDD.n33 VDD.n32 0.08425
R1021 VDD.n172 VDD.n149 0.083
R1022 VDD.n66 VDD.n43 0.083
R1023 VDD.n51 VDD.n48 0.083
R1024 VDD.n141 VDD.n120 0.083
R1025 VDD.n27 VDD 0.082144
R1026 VDD.n179 VDD.n178 0.08175
R1027 VDD.n2 VDD.n1 0.08175
R1028 VDD.n85 VDD.n48 0.078
R1029 VDD.n117 VDD.n38 0.077144
R1030 VDD.n10 VDD 0.075894
R1031 VDD.n78 VDD.n45 0.073
R1032 VDD.n93 VDD.n57 0.072144
R1033 VDD.n90 VDD.n56 0.069644
R1034 VDD.n59 VDD.n47 0.06925
R1035 VDD.n22 VDD 0.063
R1036 VDD.n61 VDD.n46 0.059644
R1037 VDD.n109 VDD.n39 0.058394
R1038 VDD.n78 VDD.n44 0.055894
R1039 VDD.n49 VDD 0.05175
R1040 VDD.n27 VDD.n26 0.049644
R1041 VDD VDD.n2 0.04925
R1042 VDD.n170 VDD.n149 0.048
R1043 VDD.n64 VDD.n43 0.048
R1044 VDD.n62 VDD.n45 0.048
R1045 VDD.n139 VDD.n120 0.048
R1046 VDD.n28 VDD.n4 0.047144
R1047 VDD.n32 VDD 0.04675
R1048 VDD VDD.n8 0.0455
R1049 VDD.n31 VDD.n30 0.044644
R1050 VDD.n153 VDD 0.038
R1051 VDD VDD.n0 0.03675
R1052 VDD.n103 VDD.n102 0.02675
R1053 VDD.n81 VDD.n49 0.02425
R1054 VDD.n90 VDD.n89 0.02175
R1055 VDD.n15 VDD.n8 0.01175
R1056 VDD.n77 VDD.n47 0.008
R1057 VDD.n153 VDD.n152 0.0055
R1058 VDD.n183 VDD.n1 0.00425
R1059 VDD.t2 VDD.n181 0.001
R1060 VDD.n181 VDD.t29 0.001
R1061 a_1267_5853.n3 a_1267_5853.t2 62.1316
R1062 a_1267_5853.n0 a_1267_5853.t4 33.8246
R1063 a_1267_5853.n2 a_1267_5853.n1 30.9319
R1064 a_1267_5853.n1 a_1267_5853.t3 24.2519
R1065 a_1267_5853.n0 a_1267_5853.t5 15.0005
R1066 a_1267_5853.n1 a_1267_5853.n0 9.7067
R1067 a_1267_5853.t0 a_1267_5853.n3 6.4499
R1068 a_1267_5853.n2 a_1267_5853.t1 2.74809
R1069 a_1267_5853.n3 a_1267_5853.n2 1.0385
R1070 a_917_8508.n1 a_917_8508.t4 35.7362
R1071 a_917_8508.n0 a_917_8508.t5 35.7056
R1072 a_917_8508.n0 a_917_8508.t3 33.3019
R1073 a_917_8508.n1 a_917_8508.t6 33.3019
R1074 a_917_8508.n3 a_917_8508.t7 24.0005
R1075 a_917_8508.n4 a_917_8508.t0 15.0005
R1076 a_917_8508.n4 a_917_8508.n3 10.0675
R1077 a_917_8508.n3 a_917_8508.n2 9.3019
R1078 a_917_8508.n4 a_917_8508.t2 6.73832
R1079 a_917_8508.t1 a_917_8508.n4 3.45748
R1080 a_917_8508.n2 a_917_8508.n0 2.44159
R1081 a_917_8508.n2 a_917_8508.n1 2.40639
R1082 Ven.n0 Ven.t6 24.1567
R1083 Ven.n0 Ven 6.4135
R1084 RST Ven.n0 2.8957
R1085 vCMP.n1 vCMP.t4 26.5921
R1086 vCMP.n2 vCMP.t2 24.0005
R1087 vCMP.n1 vCMP.t3 24.0005
R1088 Vout vCMP.n0 9.4053
R1089 vCMP.n0 vCMP.t0 6.42431
R1090 vCMP.n2 vCMP.n1 3.8527
R1091 vCMP.n0 vCMP.t1 3.74891
R1092 vCMP.n3 vCMP.n2 0.210841
R1093 vCMP.n3 vCMP 0.0434268
R1094 Vout vCMP.n3 0.0269
R1095 VOUT.n2 VOUT.t0 34.3473
R1096 VOUT.n11 VOUT.t12 24.3349
R1097 VOUT.n11 VOUT.t11 24.0005
R1098 VOUT VOUT.n10 19.6392
R1099 VOUT.n3 VOUT.t6 15.2221
R1100 VOUT.n5 VOUT.t9 15.2221
R1101 VOUT.n8 VOUT.t8 15.2221
R1102 VOUT.n0 VOUT.t7 15.2221
R1103 VOUT.n1 VOUT.t2 15.2221
R1104 VOUT.n3 VOUT.t3 15.1689
R1105 VOUT.n5 VOUT.t5 15.1689
R1106 VOUT.n8 VOUT.t10 15.1689
R1107 VOUT.n0 VOUT.t4 15.1689
R1108 VOUT.n1 VOUT.t1 15.1689
R1109 VOUT.n9 VOUT.n8 14.5626
R1110 VOUT.n10 VOUT.n9 10.2182
R1111 VOUT.n4 VOUT 9.02372
R1112 VOUT.n2 VOUT 9.02372
R1113 VOUT.n7 VOUT.n6 9.0005
R1114 VOUT.n6 VOUT.n5 5.56192
R1115 VOUT.n10 VOUT.n0 5.56192
R1116 VOUT VOUT.n3 5.53939
R1117 VOUT VOUT.n1 5.53939
R1118 VOUT.n9 VOUT.n7 1.2358
R1119 VOUT.n4 VOUT.n2 1.2347
R1120 VOUT.n7 VOUT.n4 1.2182
R1121 VOUT.n6 MEM 0.50439
R1122 VOUT VOUT.n11 0.0896
R1123 SPIKE.n2 SPIKE.n0 9.44825
R1124 SPIKE.n2 SPIKE.n1 9.00165
R1125 SPIKE.n1 SPIKE.t0 5.78405
R1126 SPIKE.n0 SPIKE.t1 5.78362
R1127 SPIKE.n1 SPIKE.t3 4.44314
R1128 SPIKE.n0 SPIKE.t2 4.44314
R1129 Vspk SPIKE.n2 2.5723
R1130 Vspk SPIKE 1.2061
R1131 Vctr.n5 Vctr.t0 46.1463
R1132 Vctr.n1 Vctr.t4 36.8093
R1133 Vctr.n0 Vctr.t3 35.0905
R1134 Vctr.n0 Vctr.t5 33.5021
R1135 Vctr.n2 Vctr.t2 33.5021
R1136 Vctr.n1 Vctr.t1 33.5021
R1137 Vctr.n4 Vctr.n3 28.8641
R1138 Vctr.n4 Vctr.t6 24.1891
R1139 Vctr.n3 Vctr.n0 3.0981
R1140 Vctr.n2 Vctr.n1 1.5889
R1141 Vctr Vctr.n5 0.478214
R1142 Vctr.n5 Vx 0.268691
R1143 Vctr.n3 Vctr.n2 0.2161
R1144 Vctr.n6 Vctr.n4 0.13669
R1145 Vctr Vctr.n6 0.0654524
R1146 Vctr.n6 Vctr 0.0625
R1147 a_1839_5853.n2 a_1839_5853.t4 80.5918
R1148 a_1839_5853.n0 a_1839_5853.t3 24.9575
R1149 a_1839_5853.n0 a_1839_5853.t2 24.2519
R1150 a_1839_5853.n1 a_1839_5853.n0 10.4287
R1151 a_1839_5853.t0 a_1839_5853.n2 6.4499
R1152 a_1839_5853.n1 a_1839_5853.t1 2.90472
R1153 a_1839_5853.n2 a_1839_5853.n1 0.864226
R1154 a_917_6931.n3 a_917_6931.n2 38.6053
R1155 a_917_6931.n2 a_917_6931.t4 35.4418
R1156 a_917_6931.n0 a_917_6931.t6 35.4155
R1157 a_917_6931.n1 a_917_6931.t7 33.3019
R1158 a_917_6931.n2 a_917_6931.t5 33.3019
R1159 a_917_6931.n0 a_917_6931.t3 33.2887
R1160 a_917_6931.n3 a_917_6931.t1 15.0005
R1161 a_917_6931.t0 a_917_6931.n3 6.7341
R1162 a_917_6931.n3 a_917_6931.t2 3.46158
R1163 a_917_6931.n1 a_917_6931.n0 2.14693
R1164 a_917_6931.n2 a_917_6931.n1 2.11633
R1165 Vref.n3 Vref.t2 36.5878
R1166 Vref.n0 Vref.t3 35.0698
R1167 Vref.n2 Vref.t0 33.5087
R1168 Vref.n1 Vref.t1 33.5087
R1169 Vref.n0 Vref.t5 33.5087
R1170 Vref.n4 Vref.n3 30.2191
R1171 Vref.n4 Vref.t4 24.187
R1172 Vref.n1 Vref.n0 3.28639
R1173 Vref.n2 Vref.n1 1.56159
R1174 Vref Vref.n4 0.203738
R1175 Vref.n3 Vref.n2 0.17999
C0 VDD a_4221_4709# 0.53963f
C1 a_4053_6587# a_4053_6375# 0.01085f
C2 RST SPIKE 0.26196f
C3 a_1369_10831# a_1267_10309# 0.21767f
C4 a_1941_10831# a_1839_10309# 0.20989f
C5 VDD a_3317_8081# 0.71603f
C6 a_3009_8081# a_2380_8081# 0.01182f
C7 a_2805_8081# a_2907_8081# 0.09917f
C8 a_4053_8603# a_4053_8388# 0.01056f
C9 VDD a_3037_11577# 0.0821f
C10 VDD a_4437_7055# 0.01146f
C11 a_2584_8081# a_1839_8081# 0.20243f
C12 vCMP SPIKE 0.51954f
C13 VDD a_2805_6967# 0.22722f
C14 Vctr a_856_11577# 0.06062f
C15 a_3037_11753# a_3037_11577# 0.13024f
C16 a_4437_10831# a_4437_10616# 0.01056f
C17 RST Ven 0.77083f
C18 a_3317_6967# a_1267_6967# 0.01031f
C19 a_3207_4709# a_2840_5276# 0.12877f
C20 a_1071_4709# a_1479_4709# 0.14353f
C21 a_2907_5853# a_2584_5853# 0.3427f
C22 a_2951_11577# VOUT 0.06704f
C23 a_3009_7689# a_2907_6967# 0.09917f
C24 a_2380_10309# a_2907_10309# 0.20088f
C25 Vref SPIKE 0.02311f
C26 vCMP Ven 0.36089f
C27 VDD a_1369_10831# 0.23062f
C28 VDD a_856_11577# 1.3931f
C29 a_856_11577# a_1988_11577# 0.05279f
C30 a_4078_11753# a_2951_11577# 0.02034f
C31 a_3317_8081# a_3521_8081# 0.40843f
C32 VDD a_1988_11753# 0.07893f
C33 vCMP a_2380_5853# 0.02344f
C34 a_2380_9195# a_2907_9195# 0.20077f
C35 a_1988_11753# a_1988_11577# 0.13024f
C36 a_4821_8603# a_4821_8815# 0.01085f
C37 a_2805_8081# a_1267_8081# 0.01675f
C38 VDD a_2907_5853# 0.18145f
C39 a_1986_11933# a_1988_11753# 0.12308f
C40 a_2380_9195# a_3317_9195# 0.0172f
C41 VDD a_1479_4709# 0.50692f
C42 a_1267_6967# a_2907_6967# 0.37474f
C43 a_2584_6967# a_2380_6967# 0.83154f
C44 VOUT a_3521_5853# 0.11072f
C45 VDD a_1742_11577# 0.13235f
C46 VDD a_2805_8603# 0.22722f
C47 VDD a_3317_6967# 0.71605f
C48 a_2584_8081# a_2584_6967# 0.07395f
C49 a_3207_4709# Ven 0.10055f
C50 a_1820_4745# a_1692_4709# 0.1987f
C51 VDD a_3009_9195# 0.22744f
C52 a_1267_6967# a_1369_6967# 0.22361f
C53 a_1839_6967# a_1941_6967# 0.20989f
C54 a_4437_9922# a_4437_9710# 0.01085f
C55 a_1369_9917# a_1267_10309# 0.02342f
C56 a_4821_8388# a_4821_8176# 0.01085f
C57 a_1941_9917# a_1839_10309# 0.02347f
C58 a_1369_10309# a_1267_10309# 0.10698f
C59 a_1941_10309# a_1839_10309# 0.1072f
C60 a_3009_5853# a_2584_5853# 0.04719f
C61 a_2907_10309# a_2805_10831# 0.20304f
C62 a_2380_9195# a_2380_10309# 0.03435f
C63 VDD a_4053_11043# 0.01376f
C64 a_2769_4709# a_2840_5276# 0.52069f
C65 vCMP a_2538_4709# 0.04697f
C66 vCMP a_3521_5853# 0.03762f
C67 a_4828_5366# VOUT 0.42342f
C68 a_1267_9195# a_1267_8081# 0.47286f
C69 VDD a_2907_6967# 0.18194f
C70 VDD a_3545_4709# 0.53126f
C71 a_2907_10309# a_1267_10309# 0.37961f
C72 a_1839_6967# a_1267_8081# 0.01066f
C73 VDD a_2380_8081# 0.52925f
C74 a_1267_9195# RST 0.05721f
C75 a_2805_8081# a_2584_8081# 0.01463f
C76 a_4078_11577# a_4078_11753# 0.13024f
C77 VDD a_1369_6967# 0.22773f
C78 RST a_1839_6967# 1.03907f
C79 VDD a_4070_11441# 0.27451f
C80 a_3026_11441# a_2951_11577# 0.01246f
C81 a_1369_8603# a_1267_8081# 0.2172f
C82 a_1941_8603# a_1839_8081# 0.21415f
C83 a_4053_10831# a_4053_10616# 0.01056f
C84 a_1839_10309# RST 0.81032f
C85 Vctr a_942_11753# 0.02912f
C86 a_3009_7689# a_2584_6967# 0.04719f
C87 a_2584_10309# a_2380_10309# 0.77156f
C88 a_4828_5366# vCMP 0.42291f
C89 a_4821_10404# a_4821_10616# 0.01085f
C90 a_2769_4709# Ven 0.33204f
C91 VDD a_2907_10309# 0.21289f
C92 VDD a_3992_11577# 0.12695f
C93 a_1267_9195# Vref 0.03021f
C94 a_2907_8081# a_3009_8603# 0.21534f
C95 a_3317_8081# a_3317_6967# 0.03047f
C96 a_1988_11753# a_856_11577# 0.02034f
C97 a_2584_9195# a_2380_9195# 0.79681f
C98 a_1267_9195# a_2907_9195# 0.37517f
C99 a_4437_8603# a_4437_8815# 0.01085f
C100 VDD a_1839_8081# 0.72034f
C101 Vref a_1839_6967# 0.20502f
C102 VDD a_942_11753# 0.07853f
C103 a_1941_8081# a_1839_8081# 0.10389f
C104 a_1369_8081# a_1267_8081# 0.1037f
C105 VDD a_3009_6375# 0.22744f
C106 a_1071_4709# SPIKE 0.12757f
C107 a_1267_9195# a_3317_9195# 0.01067f
C108 a_1839_10309# Vref 0.18656f
C109 a_1839_6967# a_2380_6967# 0.19576f
C110 a_1267_6967# a_2584_6967# 0.71176f
C111 a_2907_9195# a_3009_9917# 0.09922f
C112 a_1267_10309# a_3009_10831# 0.02044f
C113 a_1742_11577# a_856_11577# 0.02667f
C114 VDD a_2840_5276# 0.319f
C115 a_4053_8603# a_4053_8815# 0.01085f
C116 VDD a_4821_8815# 0.01146f
C117 VDD a_3521_6967# 0.72208f
C118 VDD a_4437_6587# 0.01146f
C119 VDD a_1941_9195# 0.22773f
C120 a_4053_9922# a_4053_9710# 0.01085f
C121 a_4437_7267# a_4437_7482# 0.01056f
C122 a_1071_4709# Ven 0.09224f
C123 a_3009_8603# a_1267_8081# 0.02006f
C124 RST a_1369_5853# 0.01523f
C125 a_1941_7689# a_1839_8081# 0.02364f
C126 a_1369_7689# a_1267_8081# 0.02351f
C127 a_2907_6967# a_2805_6967# 0.20304f
C128 a_2380_8081# a_3317_8081# 0.0172f
C129 vCMP a_3317_5853# 0.02406f
C130 a_2584_10309# a_2805_10831# 0.04511f
C131 VDD SPIKE 0.67431f
C132 a_2584_9195# a_2584_10309# 0.07395f
C133 a_2538_4709# a_2769_4709# 0.13146f
C134 vCMP a_1692_4709# 0.44996f
C135 VDD a_3009_10831# 0.23132f
C136 VDD a_2380_9195# 0.52955f
C137 a_4437_6160# a_4437_6375# 0.01056f
C138 a_2584_5853# a_2380_5853# 0.83117f
C139 a_1839_9195# a_1839_8081# 0.29007f
C140 VDD a_2584_6967# 0.47283f
C141 a_3521_8081# a_3521_6967# 0.02864f
C142 a_2380_10309# a_1839_10309# 0.20354f
C143 a_2584_10309# a_1267_10309# 0.678f
C144 VDD Ven 0.46026f
C145 a_2805_10309# a_2907_10309# 0.09917f
C146 a_3009_10309# a_2380_10309# 0.01182f
C147 a_2130_4709# SPIKE 0.26706f
C148 a_2907_5853# a_2907_6967# 0.02097f
C149 VDD a_1982_11441# 0.3164f
C150 a_1982_11441# a_1988_11577# 0.29085f
C151 VDD a_2380_5853# 0.53091f
C152 a_2907_8081# a_1267_8081# 0.37587f
C153 a_3009_5853# a_2907_5853# 0.09917f
C154 a_4437_8176# a_4437_8388# 0.01085f
C155 a_1267_9195# a_1369_9195# 0.22323f
C156 a_1839_9195# a_1941_9195# 0.21287f
C157 a_2805_7689# a_1267_6967# 0.01675f
C158 a_3317_6967# a_2907_6967# 0.14521f
C159 a_4078_11753# VOUT 0.03038f
C160 a_3883_4709# vCMP 0.19574f
C161 a_2130_4709# Ven 0.16603f
C162 VDD a_2584_10309# 0.48339f
C163 a_4821_10831# a_4821_11043# 0.01085f
C164 VDD a_2951_11577# 1.38087f
C165 a_1267_9195# a_2584_9195# 0.70219f
C166 a_1839_9195# a_2380_9195# 0.19537f
C167 VDD a_4437_9283# 0.01146f
C168 VDD a_3837_11577# 0.12344f
C169 a_3037_11753# a_2951_11577# 0.02034f
C170 VDD a_3030_11933# 0.11254f
C171 a_942_11753# a_856_11577# 0.02034f
C172 a_4821_7694# a_4821_7482# 0.01085f
C173 a_4821_9495# a_4821_9283# 0.01085f
C174 VDD a_1941_6375# 0.22773f
C175 a_3037_11753# a_3837_11577# 0.01566f
C176 a_3030_11933# a_3037_11753# 0.12231f
C177 a_1839_6967# a_1267_6967# 0.86515f
C178 VOUT vCMP 0.07853f
C179 a_2584_9195# a_3009_9917# 0.04702f
C180 a_1267_9195# a_1267_10309# 0.16819f
C181 a_2907_9195# a_2907_8081# 0.02097f
C182 VDD a_2538_4709# 0.47411f
C183 RST a_1267_8081# 0.14093f
C184 VDD a_4053_8815# 0.01146f
C185 VDD a_3521_5853# 0.72337f
C186 a_2907_5853# a_3009_6375# 0.21534f
C187 Vctr a_1267_9195# 0.1912f
C188 a_4221_4709# Ven 0.10042f
C189 a_4053_7267# a_4053_7482# 0.01056f
C190 a_942_11753# a_1742_11577# 0.01576f
C191 a_1267_6967# a_3009_6967# 0.01951f
C192 a_2584_6967# a_2805_6967# 0.04511f
C193 a_2584_8081# a_2907_8081# 0.34325f
C194 a_1839_10309# a_1267_10309# 0.91449f
C195 a_4437_9495# a_4437_9283# 0.01085f
C196 VOUT a_3521_10309# 0.11264f
C197 a_2130_4709# a_2538_4709# 0.13318f
C198 a_3317_10309# a_3521_10309# 0.40843f
C199 VDD a_1267_9195# 0.92452f
C200 a_4053_6160# a_4053_6375# 0.01056f
C201 Vref a_1267_8081# 0.05475f
C202 a_4437_7267# a_4437_7055# 0.01085f
C203 VDD a_1839_6967# 0.7224f
C204 a_3317_6967# a_3521_6967# 0.40843f
C205 Vref RST 0.19195f
C206 a_3317_9195# a_3317_10309# 0.03047f
C207 VDD a_4828_5366# 0.62915f
C208 a_2805_10309# a_2584_10309# 0.01463f
C209 VDD a_1839_10309# 0.73202f
C210 VDD a_1369_8603# 0.22773f
C211 a_1941_10831# a_1267_10309# 0.01376f
C212 a_1479_4709# SPIKE 0.02696f
C213 a_3009_8081# a_2907_8081# 0.09917f
C214 VDD a_4078_11577# 0.08091f
C215 VDD a_4821_7055# 0.01146f
C216 a_938_11441# a_942_11577# 0.29158f
C217 a_3037_11577# a_2951_11577# 0.05268f
C218 VDD a_3009_6967# 0.22744f
C219 a_2380_8081# a_1839_8081# 0.20529f
C220 a_2584_8081# a_1267_8081# 0.71451f
C221 a_1369_5853# a_1267_6967# 0.01488f
C222 a_1941_5853# a_1839_6967# 0.01612f
C223 a_4053_8176# a_4053_8388# 0.01085f
C224 a_3837_11577# a_3037_11577# 0.01566f
C225 a_2907_9195# a_2805_9195# 0.20304f
C226 a_1369_7689# a_1267_6967# 0.09918f
C227 a_1941_7689# a_1839_6967# 0.09918f
C228 a_3207_4709# vCMP 0.21497f
C229 a_1479_4709# Ven 0.03868f
C230 a_2907_5853# a_2380_5853# 0.19738f
C231 a_3521_6967# a_2907_6967# 0.01245f
C232 a_2380_10309# a_3317_10309# 0.0172f
C233 a_4437_10831# a_4437_11043# 0.01085f
C234 VDD a_1941_10831# 0.2311f
C235 VDD a_942_11577# 0.07892f
C236 a_856_11577# a_2951_11577# 0.07855f
C237 a_1839_9195# a_1267_9195# 0.57006f
C238 VDD a_2788_11753# 0.1011f
C239 VDD a_942_11933# 0.11246f
C240 a_4074_11933# a_4078_11753# 0.12277f
C241 a_1820_4745# VDD 0.22439f
C242 a_4437_7694# a_4437_7482# 0.01085f
C243 VDD a_3317_5853# 0.71754f
C244 a_2788_11753# a_3037_11753# 0.01498f
C245 a_4437_10616# a_4437_10404# 0.01085f
C246 a_1267_9195# a_2805_9917# 0.01675f
C247 a_2907_9195# a_3317_9195# 0.14521f
C248 a_1839_9195# a_1839_10309# 0.23596f
C249 a_2584_6967# a_2907_6967# 0.34325f
C250 VDD a_1692_4709# 0.13567f
C251 VDD a_3009_8603# 0.22744f
C252 a_4821_7267# a_4821_7482# 0.01056f
C253 a_3545_4709# Ven 0.09932f
C254 a_1267_6967# a_1941_6967# 0.01432f
C255 a_4053_9495# a_4053_9283# 0.01085f
C256 a_3009_5853# a_2380_5853# 0.01182f
C257 a_3521_5853# a_2907_5853# 0.01245f
C258 a_1692_4709# a_2130_4709# 0.0123f
C259 a_2907_10309# a_3009_10831# 0.21534f
C260 a_4821_6375# a_4821_6587# 0.01085f
C261 vCMP a_2769_4709# 0.14498f
C262 VDD a_4437_11043# 0.01277f
C263 a_4053_7267# a_4053_7055# 0.01085f
C264 a_3521_9195# VOUT 0.11264f
C265 VDD a_3883_4709# 0.53346f
C266 a_3317_10309# a_1267_10309# 0.01121f
C267 a_1267_6967# a_1267_8081# 0.229f
C268 VDD a_2907_8081# 0.18158f
C269 a_3009_8081# a_2584_8081# 0.04719f
C270 VDD a_4053_7055# 0.01146f
C271 VDD a_1941_6967# 0.22773f
C272 RST a_1267_6967# 0.06926f
C273 a_1941_8603# a_1267_8081# 0.01308f
C274 RST a_1071_4709# 0.41482f
C275 a_4821_6160# a_4821_5948# 0.01085f
C276 a_2584_9195# a_2805_9195# 0.04511f
C277 a_1267_9195# a_3009_9195# 0.01987f
C278 Vctr a_1267_8081# 0.19727f
C279 a_1267_10309# RST 0.11277f
C280 VDD VOUT 5.51995f
C281 a_3009_7689# a_2380_6967# 0.01182f
C282 a_2584_10309# a_2907_10309# 0.3331f
C283 a_2805_7689# a_2907_6967# 0.09917f
C284 a_4053_10831# a_4053_11043# 0.01085f
C285 a_2897_5460# vCMP 0.04778f
C286 a_2840_5276# Ven 0.05759f
C287 VDD a_3317_10309# 0.73395f
C288 Vctr RST 5.89674f
C289 VDD a_4078_11753# 0.07927f
C290 a_856_11577# a_942_11577# 0.05257f
C291 a_3992_11577# a_2951_11577# 0.02647f
C292 a_2907_8081# a_3521_8081# 0.01245f
C293 VDD a_1902_11577# 0.13047f
C294 a_1902_11577# a_1988_11577# 0.01553f
C295 a_2584_9195# a_2907_9195# 0.33207f
C296 a_2788_11753# a_856_11577# 0.03808f
C297 a_3837_11577# a_3992_11577# 0.15242f
C298 vCMP a_2584_5853# 0.04263f
C299 Vref a_1267_6967# 0.04432f
C300 VDD a_1267_8081# 0.78139f
C301 a_4053_7694# a_4053_7482# 0.01085f
C302 a_1988_11753# a_2788_11753# 0.0151f
C303 a_4053_10616# a_4053_10404# 0.01085f
C304 VDD RST 1.07636f
C305 a_1267_10309# Vref 0.01098f
C306 Ven SPIKE 0.07255f
C307 a_1839_9195# a_1941_9917# 0.09921f
C308 a_1267_9195# a_1369_9917# 0.09919f
C309 a_1267_6967# a_2380_6967# 0.624f
C310 a_1839_6967# a_2907_6967# 0.01463f
C311 VOUT a_3521_8081# 0.11264f
C312 a_3521_9195# a_3521_10309# 0.02864f
C313 a_2907_9195# a_3521_9195# 0.01245f
C314 a_1742_11577# a_942_11577# 0.01576f
C315 a_4821_9710# a_4821_9495# 0.01056f
C316 Vctr Vref 0.1239f
C317 VDD vCMP 0.88059f
C318 a_2907_5853# a_3317_5853# 0.14521f
C319 a_3883_4709# a_4221_4709# 0.15167f
C320 VDD a_4821_6587# 0.01146f
C321 VDD a_2805_9195# 0.22722f
C322 a_3317_9195# a_3521_9195# 0.40843f
C323 a_2907_6967# a_3009_6967# 0.21534f
C324 a_2907_8081# a_3317_8081# 0.14521f
C325 a_2805_5853# a_2584_5853# 0.01463f
C326 a_3317_5853# a_3317_6967# 0.01806f
C327 VDD Vref 0.14311f
C328 a_1479_4709# a_1692_4709# 0.13829f
C329 vCMP a_2130_4709# 0.32329f
C330 a_2538_4709# a_2840_5276# 0.02801f
C331 VDD a_3521_10309# 0.78165f
C332 VDD a_2907_9195# 0.18206f
C333 a_4821_7267# a_4821_7055# 0.01085f
C334 a_4078_11577# a_4070_11441# 0.29012f
C335 a_4437_9710# a_4437_9495# 0.01056f
C336 a_1839_9195# a_1267_8081# 0.03204f
C337 a_1267_9195# a_1839_8081# 0.01817f
C338 VDD a_2380_6967# 0.52925f
C339 VDD a_3207_4709# 0.52782f
C340 a_3521_5853# a_3521_6967# 0.03719f
C341 VDD a_3317_9195# 0.71609f
C342 a_1839_6967# a_1839_8081# 0.2476f
C343 a_2380_10309# a_1267_10309# 0.63065f
C344 a_1839_9195# RST 1.10731f
C345 VDD a_2584_8081# 0.4728f
C346 a_2907_10309# a_1839_10309# 0.01075f
C347 a_3009_10309# a_2907_10309# 0.0992f
C348 a_4078_11577# a_3992_11577# 0.0157f
C349 VDD a_3026_11441# 0.31359f
C350 a_3317_8081# a_1267_8081# 0.01086f
C351 a_4437_6160# a_4437_5948# 0.01085f
C352 a_1267_9195# a_1941_9195# 0.01706f
C353 a_2805_7689# a_2584_6967# 0.01463f
C354 a_2897_5460# a_2769_4709# 0.09977f
C355 a_4221_4709# vCMP 0.33802f
C356 a_2805_6375# a_2584_5853# 0.04511f
C357 a_2538_4709# Ven 0.024f
C358 VDD a_2380_10309# 0.53296f
C359 a_2907_8081# a_2805_8603# 0.20304f
C360 a_1839_9195# Vref 0.17487f
C361 a_1902_11577# a_856_11577# 0.02657f
C362 a_1267_9195# a_2380_9195# 0.63385f
C363 a_1839_9195# a_2907_9195# 0.01489f
C364 a_1267_10309# a_1369_9195# 0.01956f
C365 a_1839_10309# a_1941_9195# 0.01707f
C366 VDD a_4821_9283# 0.01146f
C367 a_3837_11577# a_2951_11577# 0.02645f
C368 VDD a_4074_11933# 0.1125f
C369 a_942_11753# a_942_11577# 0.13024f
C370 a_1902_11577# a_1988_11753# 0.01553f
C371 VDD a_2805_6375# 0.22722f
C372 a_942_11933# a_942_11753# 0.12339f
C373 a_1839_6967# a_2584_6967# 0.20131f
C374 a_2380_9195# a_3009_9917# 0.01182f
C375 a_2907_9195# a_2805_9917# 0.09917f
C376 VDD a_2769_4709# 0.59703f
C377 a_3545_4709# a_3883_4709# 0.15149f
C378 VDD a_4437_8815# 0.01146f
C379 a_1742_11577# a_1902_11577# 0.14181f
C380 VDD a_4053_6587# 0.01146f
C381 a_2907_8081# a_2907_6967# 0.01112f
C382 VDD a_1369_9195# 0.22773f
C383 a_3317_9195# a_3317_8081# 0.01806f
C384 a_2380_8081# a_2907_8081# 0.19723f
C385 Vctr a_1267_6967# 0.18113f
C386 vCMP a_2907_5853# 0.01039f
C387 vCMP a_1479_4709# 0.03361f
C388 VDD a_2805_10831# 0.23237f
C389 Vctr a_1267_10309# 0.20357f
C390 VDD a_2584_9195# 0.47246f
C391 a_3037_11577# a_3026_11441# 0.28902f
C392 a_4053_9710# a_4053_9495# 0.01056f
C393 a_4821_8603# a_4821_8388# 0.01056f
C394 VDD a_1267_6967# 0.81628f
C395 VDD a_1071_4709# 0.69262f
C396 a_2584_10309# a_1839_10309# 0.20228f
C397 a_4437_6587# a_4437_6375# 0.01085f
C398 a_3009_10309# a_2584_10309# 0.04714f
C399 VDD a_3521_9195# 0.72208f
C400 VDD a_1267_10309# 0.90187f
C401 VDD a_1941_8603# 0.22763f
C402 a_1692_4709# SPIKE 0.24601f
C403 a_1369_6375# a_1267_6967# 0.03293f
C404 a_1941_6375# a_1839_6967# 0.02756f
C405 VDD a_938_11441# 0.31717f
C406 VDD a_2584_5853# 0.47437f
C407 a_1820_4745# Ven 0.05784f
C408 a_4078_11577# a_2951_11577# 0.05264f
C409 a_2907_8081# a_1839_8081# 0.01582f
C410 a_2805_5853# a_2907_5853# 0.09917f
C411 a_2380_8081# a_1267_8081# 0.59629f
C412 VDD Vctr 0.28439f
C413 a_4053_6160# a_4053_5948# 0.01085f
C414 a_4821_10831# a_4821_10616# 0.01056f
C415 a_1941_6967# a_1839_8081# 0.01698f
C416 a_1369_6967# a_1267_8081# 0.01878f
C417 a_2907_9195# a_3009_9195# 0.21534f
C418 a_3317_6967# a_2380_6967# 0.0172f
C419 a_3545_4709# vCMP 0.20124f
C420 a_3317_5853# a_2380_5853# 0.0172f
C421 a_1692_4709# Ven 0.27747f
C422 a_3992_11577# a_4078_11753# 0.0157f
C423 a_2907_10309# a_3317_10309# 0.14521f
C424 a_2584_8081# a_2805_8603# 0.04511f
C425 a_3521_9195# a_3521_8081# 0.03719f
C426 VDD a_1988_11577# 0.07975f
C427 a_1839_9195# a_2584_9195# 0.20139f
C428 VDD a_4053_9283# 0.01146f
C429 VDD a_3037_11753# 0.07983f
C430 a_2788_11753# a_2951_11577# 0.03813f
C431 VDD a_1986_11933# 0.1125f
C432 VDD a_1369_6375# 0.22773f
C433 a_1839_8081# a_1267_8081# 0.8335f
C434 a_2584_9195# a_2805_9917# 0.01463f
C435 a_1839_9195# a_1267_10309# 0.01073f
C436 a_1267_9195# a_1369_8603# 0.03168f
C437 a_1839_9195# a_1941_8603# 0.02669f
C438 a_2380_6967# a_2907_6967# 0.19723f
C439 VDD a_2130_4709# 0.69478f
C440 VOUT a_3521_6967# 0.11264f
C441 RST a_1839_8081# 0.74487f
C442 a_3207_4709# a_3545_4709# 0.15107f
C443 VDD a_3521_8081# 0.72208f
C444 a_2907_5853# a_2805_6375# 0.20304f
C445 a_2380_8081# a_2380_6967# 0.03435f
C446 a_3883_4709# Ven 0.10008f
C447 a_4821_6375# a_4821_6160# 0.01056f
C448 a_2584_8081# a_2380_8081# 0.83154f
C449 a_4821_9922# a_4821_9710# 0.01085f
C450 a_2805_10309# a_1267_10309# 0.01675f
C451 a_3521_5853# a_3317_5853# 0.40843f
C452 VDD a_1839_9195# 0.73456f
C453 a_2907_10309# a_3521_10309# 0.01245f
C454 a_2907_9195# a_2907_10309# 0.01112f
C455 a_1267_9195# a_1369_8081# 0.01603f
C456 vCMP a_2840_5276# 0.40302f
C457 VDD a_4821_11043# 0.01522f
C458 a_1839_9195# a_1941_8081# 0.01613f
C459 a_4437_8603# a_4437_8388# 0.01056f
C460 Vref a_1839_8081# 0.21424f
C461 SPIKE VSS 0.8895f
C462 Ven VSS 3.91084f
C463 RST VSS 5.19048f
C464 vCMP VSS 2.09299f
C465 Vref VSS 2.33754f
C466 VOUT VSS 6.31815f
C467 MEM VSS 0.1134f
C468 Vctr VSS 3.11181f
C469 Vx VSS 0.03839f
C470 VDD VSS 11.2252f
C471 a_1820_4745# VSS 0.01178f
C472 a_2897_5460# VSS 0.13184f
C473 a_4828_5366# VSS 1.24238f
C474 a_4221_4709# VSS 0.84272f
C475 a_3883_4709# VSS 0.84049f
C476 a_3545_4709# VSS 0.8347f
C477 a_3207_4709# VSS 0.83521f
C478 a_2840_5276# VSS 0.53365f
C479 a_2769_4709# VSS 0.49531f
C480 a_2538_4709# VSS 0.74973f
C481 a_2130_4709# VSS 1.50643f
C482 a_1692_4709# VSS 0.71096f
C483 a_1479_4709# VSS 0.75428f
C484 a_1071_4709# VSS 1.53709f
C485 a_4821_5948# VSS 0.07575f $ **FLOATING
C486 a_4437_5948# VSS 0.07661f $ **FLOATING
C487 a_4053_5948# VSS 0.07747f $ **FLOATING
C488 a_3009_5853# VSS 0.1325f
C489 a_2805_5853# VSS 0.1338f
C490 a_1941_5853# VSS 0.13359f
C491 a_1369_5853# VSS 0.13359f
C492 a_4821_6160# VSS 0.06338f $ **FLOATING
C493 a_4437_6160# VSS 0.04522f $ **FLOATING
C494 a_4053_6160# VSS 0.06332f $ **FLOATING
C495 a_4821_6375# VSS 0.06277f $ **FLOATING
C496 a_4437_6375# VSS 0.04472f $ **FLOATING
C497 a_4053_6375# VSS 0.06272f $ **FLOATING
C498 a_4821_6587# VSS 0.06281f $ **FLOATING
C499 a_4437_6587# VSS 0.06224f $ **FLOATING
C500 a_4053_6587# VSS 0.06276f $ **FLOATING
C501 a_3521_5853# VSS 1.12436f
C502 a_3009_6375# VSS 0.01316f
C503 a_2805_6375# VSS 0.01208f
C504 a_1941_6375# VSS 0.01246f
C505 a_1369_6375# VSS 0.0124f
C506 a_3317_5853# VSS 1.5535f
C507 a_2907_5853# VSS 0.57425f
C508 a_2380_5853# VSS 0.81822f
C509 a_2584_5853# VSS 0.76189f
C510 a_4821_7055# VSS 0.06281f $ **FLOATING
C511 a_4437_7055# VSS 0.06224f $ **FLOATING
C512 a_4053_7055# VSS 0.06276f $ **FLOATING
C513 a_4821_7267# VSS 0.06277f $ **FLOATING
C514 a_4437_7267# VSS 0.04472f $ **FLOATING
C515 a_4053_7267# VSS 0.06272f $ **FLOATING
C516 a_3009_6967# VSS 0.01316f
C517 a_2805_6967# VSS 0.01208f
C518 a_1941_6967# VSS 0.01249f
C519 a_1369_6967# VSS 0.01243f
C520 a_4821_7482# VSS 0.06338f $ **FLOATING
C521 a_4437_7482# VSS 0.04522f $ **FLOATING
C522 a_4053_7482# VSS 0.06332f $ **FLOATING
C523 a_4821_7694# VSS 0.07459f $ **FLOATING
C524 a_4437_7694# VSS 0.0735f $ **FLOATING
C525 a_4053_7694# VSS 0.07453f $ **FLOATING
C526 a_3521_6967# VSS 1.13463f
C527 a_3009_7689# VSS 0.1325f
C528 a_2805_7689# VSS 0.1338f
C529 a_1941_7689# VSS 0.13359f
C530 a_1369_7689# VSS 0.13359f
C531 a_3317_6967# VSS 1.55102f
C532 a_2907_6967# VSS 0.57945f
C533 a_2380_6967# VSS 0.80986f
C534 a_2584_6967# VSS 0.74975f
C535 a_1267_6967# VSS 1.67369f
C536 a_1839_6967# VSS 1.61047f
C537 a_4821_8176# VSS 0.07459f $ **FLOATING
C538 a_4437_8176# VSS 0.0735f $ **FLOATING
C539 a_4053_8176# VSS 0.07453f $ **FLOATING
C540 a_3009_8081# VSS 0.1325f
C541 a_2805_8081# VSS 0.1338f
C542 a_1941_8081# VSS 0.13359f
C543 a_1369_8081# VSS 0.13359f
C544 a_4821_8388# VSS 0.06338f $ **FLOATING
C545 a_4437_8388# VSS 0.04522f $ **FLOATING
C546 a_4053_8388# VSS 0.06332f $ **FLOATING
C547 a_4821_8603# VSS 0.06277f $ **FLOATING
C548 a_4437_8603# VSS 0.04472f $ **FLOATING
C549 a_4053_8603# VSS 0.06272f $ **FLOATING
C550 a_4821_8815# VSS 0.06281f $ **FLOATING
C551 a_4437_8815# VSS 0.06224f $ **FLOATING
C552 a_4053_8815# VSS 0.06276f $ **FLOATING
C553 a_3521_8081# VSS 1.13463f
C554 a_3009_8603# VSS 0.01316f
C555 a_2805_8603# VSS 0.01208f
C556 a_1941_8603# VSS 0.01246f
C557 a_1369_8603# VSS 0.01232f
C558 a_3317_8081# VSS 1.551f
C559 a_2907_8081# VSS 0.57894f
C560 a_2380_8081# VSS 0.80973f
C561 a_2584_8081# VSS 0.74966f
C562 a_1267_8081# VSS 1.65867f
C563 a_1839_8081# VSS 1.6092f
C564 a_4821_9283# VSS 0.06281f $ **FLOATING
C565 a_4437_9283# VSS 0.06224f $ **FLOATING
C566 a_4053_9283# VSS 0.06276f $ **FLOATING
C567 a_4821_9495# VSS 0.06277f $ **FLOATING
C568 a_4437_9495# VSS 0.04472f $ **FLOATING
C569 a_4053_9495# VSS 0.06272f $ **FLOATING
C570 a_3009_9195# VSS 0.01316f
C571 a_2805_9195# VSS 0.01208f
C572 a_1941_9195# VSS 0.01249f
C573 a_1369_9195# VSS 0.01249f
C574 a_4821_9710# VSS 0.06338f $ **FLOATING
C575 a_4437_9710# VSS 0.04522f $ **FLOATING
C576 a_4053_9710# VSS 0.06332f $ **FLOATING
C577 a_4821_9922# VSS 0.07459f $ **FLOATING
C578 a_4437_9922# VSS 0.0735f $ **FLOATING
C579 a_4053_9922# VSS 0.07453f $ **FLOATING
C580 a_3521_9195# VSS 1.13463f
C581 a_3009_9917# VSS 0.1325f
C582 a_2805_9917# VSS 0.1338f
C583 a_1941_9917# VSS 0.13359f
C584 a_1369_9917# VSS 0.13359f
C585 a_3317_9195# VSS 1.55102f
C586 a_2907_9195# VSS 0.58045f
C587 a_2380_9195# VSS 0.81089f
C588 a_2584_9195# VSS 0.74943f
C589 a_1267_9195# VSS 1.69514f
C590 a_1839_9195# VSS 1.60298f
C591 a_4821_10404# VSS 0.07459f $ **FLOATING
C592 a_4437_10404# VSS 0.0735f $ **FLOATING
C593 a_4053_10404# VSS 0.07453f $ **FLOATING
C594 a_3009_10309# VSS 0.1325f
C595 a_2805_10309# VSS 0.1338f
C596 a_1941_10309# VSS 0.13359f
C597 a_1369_10309# VSS 0.13359f
C598 a_4821_10616# VSS 0.06338f $ **FLOATING
C599 a_4437_10616# VSS 0.04522f $ **FLOATING
C600 a_4053_10616# VSS 0.06332f $ **FLOATING
C601 a_4821_10831# VSS 0.06277f $ **FLOATING
C602 a_4437_10831# VSS 0.04472f $ **FLOATING
C603 a_4053_10831# VSS 0.06272f $ **FLOATING
C604 a_4821_11043# VSS 0.06189f $ **FLOATING
C605 a_4437_11043# VSS 0.06132f $ **FLOATING
C606 a_4053_11043# VSS 0.06184f $ **FLOATING
C607 a_3521_10309# VSS 1.12327f
C608 a_3009_10831# VSS 0.01316f
C609 a_2805_10831# VSS 0.01208f
C610 a_1941_10831# VSS 0.01249f
C611 a_1369_10831# VSS 0.01249f
C612 a_3317_10309# VSS 1.55049f
C613 a_2907_10309# VSS 0.58237f
C614 a_2380_10309# VSS 0.81342f
C615 a_2584_10309# VSS 0.75318f
C616 a_1267_10309# VSS 1.74128f
C617 a_1839_10309# VSS 1.64219f
C618 a_4070_11441# VSS 0.29059f $ **FLOATING
C619 a_3026_11441# VSS 0.25442f $ **FLOATING
C620 a_1982_11441# VSS 0.2573f $ **FLOATING
C621 a_938_11441# VSS 0.25781f $ **FLOATING
C622 a_4078_11577# VSS 0.27596f $ **FLOATING
C623 a_3037_11577# VSS 0.27596f $ **FLOATING
C624 a_2951_11577# VSS 0.19951f
C625 a_1988_11577# VSS 0.27596f $ **FLOATING
C626 a_942_11577# VSS 0.27596f $ **FLOATING
C627 a_856_11577# VSS 0.19879f
C628 a_4078_11753# VSS 0.3106f $ **FLOATING
C629 a_3992_11577# VSS 0.10259f
C630 a_3837_11577# VSS 0.10589f
C631 a_3037_11753# VSS 0.3106f $ **FLOATING
C632 a_2788_11753# VSS 0.12239f
C633 a_1988_11753# VSS 0.3106f $ **FLOATING
C634 a_1902_11577# VSS 0.10358f
C635 a_1742_11577# VSS 0.10393f
C636 a_942_11753# VSS 0.3106f $ **FLOATING
C637 a_4074_11933# VSS 0.42223f $ **FLOATING
C638 a_3030_11933# VSS 0.42223f $ **FLOATING
C639 a_1986_11933# VSS 0.42223f $ **FLOATING
C640 a_942_11933# VSS 0.42223f $ **FLOATING
C641 Vref.t4 VSS 0.32881f
C642 Vref.t3 VSS 0.35454f
C643 Vref.t5 VSS 0.3234f
C644 Vref.n0 VSS 1.86385f
C645 Vref.t1 VSS 0.3234f
C646 Vref.n1 VSS 1.28012f
C647 Vref.t0 VSS 0.3234f
C648 Vref.n2 VSS 0.62598f
C649 Vref.t2 VSS 0.40088f
C650 Vref.n3 VSS 2.51576f
C651 Vref.n4 VSS 0.81108f
C652 a_917_6931.t6 VSS 0.21359f
C653 a_917_6931.t3 VSS 0.19196f
C654 a_917_6931.n0 VSS 0.94594f
C655 a_917_6931.t7 VSS 0.19267f
C656 a_917_6931.n1 VSS 0.61666f
C657 a_917_6931.t5 VSS 0.19267f
C658 a_917_6931.t4 VSS 0.21454f
C659 a_917_6931.n2 VSS 1.35218f
C660 a_917_6931.t2 VSS 0.31382f
C661 a_917_6931.t1 VSS 0.16519f
C662 a_917_6931.n3 VSS 0.54056f
C663 a_917_6931.t0 VSS 0.16021f
C664 a_1839_5853.t1 VSS 0.30908f
C665 a_1839_5853.t3 VSS 0.26128f
C666 a_1839_5853.t2 VSS 0.27295f
C667 a_1839_5853.n0 VSS 0.5f
C668 a_1839_5853.n1 VSS 0.15774f
C669 a_1839_5853.t4 VSS 1.431f
C670 a_1839_5853.n2 VSS 1.30613f
C671 a_1839_5853.t0 VSS 0.16182f
C672 Vctr.t6 VSS 0.20225f
C673 Vctr.t3 VSS 0.21345f
C674 Vctr.t5 VSS 0.19477f
C675 Vctr.n0 VSS 1.08125f
C676 Vctr.t4 VSS 0.24649f
C677 Vctr.t1 VSS 0.19477f
C678 Vctr.n1 VSS 1.29124f
C679 Vctr.t2 VSS 0.19477f
C680 Vctr.n2 VSS 0.3643f
C681 Vctr.n3 VSS 0.8194f
C682 Vctr.n4 VSS 0.3744f
C683 Vctr.t0 VSS 1.34173f
C684 Vctr.n5 VSS 3.33544f
C685 Vctr.n6 VSS 0.03853f
C686 VOUT.t4 VSS 0.0484f
C687 VOUT.t7 VSS 0.04858f
C688 VOUT.n0 VSS 0.10977f
C689 VOUT.t0 VSS 0.09689f
C690 VOUT.t1 VSS 0.0484f
C691 VOUT.t2 VSS 0.04858f
C692 VOUT.n1 VSS 0.1094f
C693 VOUT.n2 VSS 0.79459f
C694 VOUT.t6 VSS 0.04858f
C695 VOUT.t3 VSS 0.0484f
C696 VOUT.n3 VSS 0.1094f
C697 VOUT.n4 VSS 0.49827f
C698 VOUT.t5 VSS 0.0484f
C699 VOUT.t9 VSS 0.04858f
C700 VOUT.n5 VSS 0.10977f
C701 VOUT.n6 VSS 0.17998f
C702 VOUT.n7 VSS 0.49844f
C703 VOUT.t8 VSS 0.04858f
C704 VOUT.t10 VSS 0.0484f
C705 VOUT.n8 VSS 0.17788f
C706 VOUT.n9 VSS 0.77186f
C707 VOUT.n10 VSS 0.51667f
C708 VOUT.t12 VSS 0.14303f
C709 VOUT.t11 VSS 0.14876f
C710 VOUT.n11 VSS 0.08731f
C711 Ven.t6 VSS 1.30313f
C712 Ven.n0 VSS 4.61916f
C713 a_917_8508.t5 VSS 0.1985f
C714 a_917_8508.t3 VSS 0.17815f
C715 a_917_8508.n0 VSS 0.79953f
C716 a_917_8508.t4 VSS 0.19934f
C717 a_917_8508.t6 VSS 0.17815f
C718 a_917_8508.n1 VSS 0.80229f
C719 a_917_8508.n2 VSS 0.44572f
C720 a_917_8508.t7 VSS 0.15078f
C721 a_917_8508.n3 VSS 0.27714f
C722 a_917_8508.t2 VSS 0.1482f
C723 a_917_8508.t0 VSS 0.15249f
C724 a_917_8508.n4 VSS 0.27966f
C725 a_917_8508.t1 VSS 0.29005f
C726 a_1267_5853.t1 VSS 0.28187f
C727 a_1267_5853.t4 VSS 0.18516f
C728 a_1267_5853.t5 VSS 0.0837f
C729 a_1267_5853.n0 VSS 0.14597f
C730 a_1267_5853.t3 VSS 0.25186f
C731 a_1267_5853.n1 VSS 0.4767f
C732 a_1267_5853.n2 VSS 0.46461f
C733 a_1267_5853.t2 VSS 1.00784f
C734 a_1267_5853.n3 VSS 1.35299f
C735 a_1267_5853.t0 VSS 0.14931f
C736 VDD.t29 VSS 0.03597f
C737 VDD.t13 VSS 0.63563f
C738 VDD.n116 VSS 0.07309f
C739 VDD.n117 VSS 0.01006f
C740 VDD.n118 VSS 0.02003f
C741 VDD.n127 VSS 0.01211f
C742 VDD.n133 VSS 0.01154f
C743 VDD.n134 VSS 0.01098f
C744 VDD.n136 VSS 0.01039f
C745 VDD.n138 VSS 0.01209f
C746 VDD.n139 VSS 0.01086f
C747 VDD.n142 VSS 0.01043f
C748 VDD.t4 VSS 1.03356f
C749 VDD.n144 VSS 0.06697f
C750 VDD.n145 VSS 0.02858f
C751 VDD.n146 VSS 0.03844f
C752 VDD.n147 VSS 0.02003f
C753 VDD.n158 VSS 0.01211f
C754 VDD.n164 VSS 0.01154f
C755 VDD.n165 VSS 0.01098f
C756 VDD.n167 VSS 0.01039f
C757 VDD.n169 VSS 0.01209f
C758 VDD.n170 VSS 0.01086f
C759 VDD.n173 VSS 0.01043f
C760 VDD.t6 VSS 1.03471f
C761 VDD.n175 VSS 0.07286f
C762 VDD.n176 VSS 0.02862f
C763 VDD.n177 VSS 0.03861f
C764 VDD.t2 VSS 0.79425f
C765 VDD.n182 VSS 0.0655f
.ends
