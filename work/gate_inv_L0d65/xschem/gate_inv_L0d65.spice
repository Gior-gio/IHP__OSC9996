** sch_path: /foss/designs/chipathon_2025/designs/ihp-sg13g2/gate_inv_L0d65/xschem/gate_inv_L0d65.sch
.subckt gate_inv_L0d65 VDD B A VSS
*.PININFO B:O A:I VDD:B VSS:B
MN B A VSS VSS sg13_lv_nmos w=1u l=0.65u ng=1 m=1
MP B A VDD VDD sg13_lv_pmos w=2u l=0.65u ng=1 m=1
.ends
