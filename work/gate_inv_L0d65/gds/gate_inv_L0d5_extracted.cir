* Extracted by KLayout with SG13G2 LVS runset on : 30/01/2026 23:40

.SUBCKT gate_inv_L0d5 VSS B A VDD
M$1 VSS A B VSS sg13_lv_nmos L=0.65u W=1u AS=0.34p AD=0.34p PS=2.68u PD=2.68u
M$2 VDD A B VDD sg13_lv_pmos L=0.65u W=2u AS=0.68p AD=0.68p PS=4.68u PD=4.68u
.ENDS gate_inv_L0d5
