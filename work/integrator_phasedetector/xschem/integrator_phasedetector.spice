** sch_path: /foss/designs/chipathon_2025/designs/ihp-sg13g2/integrator_phasedetector/xschem/integrator_phasedetector.sch
.subckt integrator_phasedetector VDD A VOUT B VSS
*.PININFO A:I B:I VSS:I VDD:I VOUT:O
x1 VDD net2 B A VSS gate_xor
x2 VDD net2 net1 VSS gate_buff_L0d13
RXOR VOUT net1 rppd w=0.5e-6 l=0.5e-6 m=2 b=0
RXOR1 VSS VSS rppd w=0.5e-6 l=0.5e-6 m=10 b=0
.ends

* expanding   symbol:  /foss/designs/chipathon_2025/designs/ihp-sg13g2/gate_xor/xschem/gate_xor.sym # of pins=5
** sym_path: /foss/designs/chipathon_2025/designs/ihp-sg13g2/gate_xor/xschem/gate_xor.sym
** sch_path: /foss/designs/chipathon_2025/designs/ihp-sg13g2/gate_xor/xschem/gate_xor.sch
.subckt gate_xor VDD S B A VSS
*.PININFO VSS:I B:I A:I VDD:I S:O
M2 net1 A VDD VDD sg13_lv_pmos w=2u l=0.13u ng=1 m=1
M1 S -B net1 VDD sg13_lv_pmos w=2u l=0.13u ng=1 m=1
M4 net2 -A VDD VDD sg13_lv_pmos w=2u l=0.13u ng=1 m=1
M5 S B net2 VDD sg13_lv_pmos w=2u l=0.13u ng=1 m=1
M6 S B net4 VSS sg13_lv_nmos w=1.0u l=0.13u ng=1 m=1
M3 net4 A VSS VSS sg13_lv_nmos w=1.0u l=0.13u ng=1 m=1
M7 S -B net3 VSS sg13_lv_nmos w=1.0u l=0.13u ng=1 m=1
M8 net3 -A VSS VSS sg13_lv_nmos w=1.0u l=0.13u ng=1 m=1
x3 VDD A -A VSS gate_inv_L0d13
x1 VDD B -B VSS gate_inv_L0d13
.ends

* expanding   symbol:  /foss/designs/chipathon_2025/designs/ihp-sg13g2/gate_buff_L0d13/xschem/gate_buff_L0d13.sym # of pins=4
** sym_path: /foss/designs/chipathon_2025/designs/ihp-sg13g2/gate_buff_L0d13/xschem/gate_buff_L0d13.sym
** sch_path: /foss/designs/chipathon_2025/designs/ihp-sg13g2/gate_buff_L0d13/xschem/gate_buff_L0d13.sch
.subckt gate_buff_L0d13 VDD VIN VOUT VSS
*.PININFO VDD:I VIN:I VSS:I VOUT:O
M1 net1 VIN VSS VSS sg13_lv_nmos w=1.0u l=0.13u ng=1 m=1
M2 net1 VIN VDD VDD sg13_lv_pmos w=2u l=0.13u ng=1 m=1
M3 VOUT net1 VSS VSS sg13_lv_nmos w=1.0u l=0.13u ng=1 m=3
M4 VOUT net1 VDD VDD sg13_lv_pmos w=2u l=0.13u ng=1 m=3
.ends

* expanding   symbol:  /foss/designs/chipathon_2025/designs/ihp-sg13g2/gate_inv_L0d13/xschem/gate_inv_L0d13.sym # of pins=4
** sym_path: /foss/designs/chipathon_2025/designs/ihp-sg13g2/gate_inv_L0d13/xschem/gate_inv_L0d13.sym
** sch_path: /foss/designs/chipathon_2025/designs/ihp-sg13g2/gate_inv_L0d13/xschem/gate_inv_L0d13.sch
.subckt gate_inv_L0d13 VDD VIN VOUT VSS
*.PININFO VDD:I VSS:I VIN:I VOUT:O
M2 VOUT VIN VDD VDD sg13_lv_pmos w=2u l=0.13u ng=1 m=1
M1 VOUT VIN VSS VSS sg13_lv_nmos w=1.0u l=0.13u ng=1 m=1
.ends
