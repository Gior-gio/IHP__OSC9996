** sch_path: /foss/designs/chipathon_2025/designs/ihp-sg13g2/gate_inv_L0d13/xschem/gate_inv_L0d13.sch
.subckt gate_inv_L0d13 VDD VIN VOUT VSS
*.PININFO VDD:I VSS:I VIN:I VOUT:O
M2 VDD VIN VOUT VDD sg13_lv_pmos w=2u l=0.13u ng=1 m=1
M1 VOUT VIN VSS VSS sg13_lv_nmos w=1.0u l=0.13u ng=1 m=1
.ends
