* Extracted by KLayout with SG13G2 LVS runset on : 30/01/2026 03:31

.SUBCKT inv
M$1 \$1 \$3 \$2 \$1 sg13_lv_nmos L=0.13u W=2u AS=0.68p AD=0.68p PS=4.68u
+ PD=4.68u
M$2 \$4 \$3 \$2 \$4 sg13_lv_pmos L=0.13u W=2u AS=0.68p AD=0.68p PS=4.68u
+ PD=4.68u
.ENDS inv
