** sch_path: /foss/designs/chipathon_2025/designs/ihp-sg13g2/edge_detector/runs/RUN_2026-02-26_17-44-04/parameters/MC_Variations/run_0/run_75/CACE_edge_detector_TB.sch
**.subckt CACE_edge_detector_TB
VIN net3 GND pwl 0 0 10n 0 10.1n {VDD}
VSP net1 GND {VDD}
VSN net2 GND {VSS}
* noconn Y
R3 net3 IN 50 m=1
R1 net2 VSS 50 m=1
R2 net1 VDD 50 m=1
xEDGE IN OUT VDD VSS edge_detector
*  xLOAD -  gate_inv_L0d5  IS MISSING !!!!
**** begin user architecture code

.control
    save all

    let Vhigh = 1.2
    let Vmid = Vhigh * 0.5

    let tstop = 20n
    let tstep = tstop/10k

    * Run transient analysis
    tran $&tstep $&tstop

    * Measure rising edge time (when OUT crosses threshold upwards)
    meas tran t_rise when v(OUT)=Vmid rise=1

    * Measure falling edge time (when OUT crosses threshold downwards)
    meas tran t_fall when v(OUT)=Vmid fall=1

    * Calculate pulse width as time difference
    let pulse_width=t_fall-t_rise

    * Save output
    echo $&pulse_width > /foss/designs/chipathon_2025/designs/ihp-sg13g2/edge_detector/runs/RUN_2026-02-26_17-44-04/parameters/MC_Variations/run_0/run_75/CACE_edge_detector_TB_0.data
.endc

.lib /foss/pdks/ihp-sg13g2/libs.tech/ngspice/models/cornerMOSlv.lib mos_tt_stat
.include /foss/designs/chipathon_2025/designs/ihp-sg13g2/edge_detector/netlist/pex/edge_detector.spice

.temp 27

* Statitical switches
.param mm_ok=1
.param mc_ok=1
.option SEED=12421.0

* Flag unsafe operating conditions (exceeds models' specified limits)
.option warn=1

.param VDD = 1.2
.param VSS = 0

**** end user architecture code
**.ends

* expanding   symbol:  /foss/designs/chipathon_2025/designs/ihp-sg13g2/edge_detector/xschem/edge_detector.sym # of pins=4
** sym_path: /foss/designs/chipathon_2025/designs/ihp-sg13g2/edge_detector/xschem/edge_detector.sym
** sch_path: /foss/designs/chipathon_2025/designs/ihp-sg13g2/edge_detector/xschem/edge_detector.sch
.subckt edge_detector IN OUT VDD VSS
*.iopin VDD
*.iopin VSS
*.ipin IN
*.opin OUT
xAND IN VDD VSS OUT I4 gate_and
xINV0 VDD I0 IN VSS gate_inv_L0d65
xINV1 VDD I1 I0 VSS gate_inv_L0d65
xINV2 VDD I2 I1 VSS gate_inv_L0d65
xINV3 VDD I3 I2 VSS gate_inv_L0d65
xINV4 VDD I4 I3 VSS gate_inv_L0d65
.ends

* expanding   symbol:  /foss/designs/chipathon_2025/designs/ihp-sg13g2/gate_and/xschem/gate_and.sym # of pins=5
** sym_path: /foss/designs/chipathon_2025/designs/ihp-sg13g2/gate_and/xschem/gate_and.sym
** sch_path: /foss/designs/chipathon_2025/designs/ihp-sg13g2/gate_and/xschem/gate_and.sch
.subckt gate_and B VDD VSS OUT A
*.opin OUT
*.ipin A
*.iopin VDD
*.iopin VSS
*.ipin B
XMNB OUTN B NX VSS sg13_lv_nmos w=1u l=0.13u ng=1 m=1
XMNA NX A VSS VSS sg13_lv_nmos w=1u l=0.13u ng=1 m=1
XMPB OUTN B VDD VDD sg13_lv_pmos w=2u l=0.13u ng=1 m=1
XMPA OUTN A VDD VDD sg13_lv_pmos w=2u l=0.13u ng=1 m=1
XMNI OUT OUTN VSS VSS sg13_lv_nmos w=1u l=0.13u ng=1 m=1
XMPI OUT OUTN VDD VDD sg13_lv_pmos w=2u l=0.13u ng=1 m=1
.ends

* expanding   symbol:  /foss/designs/chipathon_2025/designs/ihp-sg13g2/gate_inv_L0d65/xschem/gate_inv_L0d65.sym # of pins=4
** sym_path: /foss/designs/chipathon_2025/designs/ihp-sg13g2/gate_inv_L0d65/xschem/gate_inv_L0d65.sym
** sch_path: /foss/designs/chipathon_2025/designs/ihp-sg13g2/gate_inv_L0d65/xschem/gate_inv_L0d65.sch
.subckt gate_inv_L0d65 VDD B A VSS
*.opin B
*.ipin A
*.iopin VDD
*.iopin VSS
XMN B A VSS VSS sg13_lv_nmos w=1u l=0.65u ng=1 m=1
XMP B A VDD VDD sg13_lv_pmos w=2u l=0.65u ng=1 m=1
.ends

.GLOBAL GND
.end
