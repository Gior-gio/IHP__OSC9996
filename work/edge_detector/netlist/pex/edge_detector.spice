* NGSPICE file created from edge_detector.ext - technology: ihp-sg13g2

.subckt pmos$1$10 a_n932_n1036# VSUB a_n906_n1000# a_n1000_n1000# w_n1062_n1062#
X0 a_n906_n1000# a_n932_n1036# a_n1000_n1000# w_n1062_n1062# sg13_lv_pmos ad=0.68p pd=4.68u as=0.68p ps=4.68u w=2u l=0.13u
C0 a_n1000_n1000# a_n906_n1000# 0.19835f
C1 w_n1062_n1062# a_n932_n1036# 0.04581f
C2 a_n906_n1000# VSUB 0.08911f
C3 a_n1000_n1000# VSUB 0.08911f
C4 a_n932_n1036# VSUB 0.20281f
.ends

.subckt pmos$1$9 a_n932_n1036# a_n802_n1000# VSUB a_n1000_n1000# w_n1062_n1062#
X0 a_n802_n1000# a_n932_n1036# a_n1000_n1000# w_n1062_n1062# sg13_lv_pmos ad=0.68p pd=4.68u as=0.68p ps=4.68u w=2u l=0.65u
C0 w_n1062_n1062# a_n932_n1036# 0.1597f
C1 a_n1000_n1000# a_n802_n1000# 0.07408f
C2 a_n802_n1000# a_n932_n1036# 0.02298f
C3 a_n1000_n1000# a_n932_n1036# 0.02298f
C4 a_n802_n1000# VSUB 0.09653f
C5 a_n1000_n1000# VSUB 0.09653f
C6 a_n932_n1036# VSUB 0.24254f
.ends

.subckt nmos$5 a_n932_n1036# a_n802_n1000# VSUB a_n1000_n1000#
X0 a_n802_n1000# a_n932_n1036# a_n1000_n1000# VSUB sg13_lv_nmos ad=0.34p pd=2.68u as=0.34p ps=2.68u w=1u l=0.65u
C0 a_n932_n1036# a_n1000_n1000# 0.01149f
C1 a_n932_n1036# a_n802_n1000# 0.01149f
C2 a_n802_n1000# a_n1000_n1000# 0.03704f
C3 a_n802_n1000# VSUB 0.05823f
C4 a_n1000_n1000# VSUB 0.05823f
C5 a_n932_n1036# VSUB 0.25633f
.ends

.subckt pmos$1$8 a_n932_n1036# a_n802_n1000# VSUB a_n1000_n1000# w_n1062_n1062#
X0 a_n802_n1000# a_n932_n1036# a_n1000_n1000# w_n1062_n1062# sg13_lv_pmos ad=0.68p pd=4.68u as=0.68p ps=4.68u w=2u l=0.65u
C0 w_n1062_n1062# a_n932_n1036# 0.1597f
C1 a_n1000_n1000# a_n802_n1000# 0.07408f
C2 a_n802_n1000# a_n932_n1036# 0.02298f
C3 a_n1000_n1000# a_n932_n1036# 0.02298f
C4 a_n802_n1000# VSUB 0.09653f
C5 a_n1000_n1000# VSUB 0.09653f
C6 a_n932_n1036# VSUB 0.24254f
.ends

.subckt nmos$4 a_n932_n1036# a_n802_n1000# VSUB a_n1000_n1000#
X0 a_n802_n1000# a_n932_n1036# a_n1000_n1000# VSUB sg13_lv_nmos ad=0.34p pd=2.68u as=0.34p ps=2.68u w=1u l=0.65u
C0 a_n932_n1036# a_n1000_n1000# 0.01149f
C1 a_n932_n1036# a_n802_n1000# 0.01149f
C2 a_n802_n1000# a_n1000_n1000# 0.03704f
C3 a_n802_n1000# VSUB 0.05823f
C4 a_n1000_n1000# VSUB 0.05823f
C5 a_n932_n1036# VSUB 0.25633f
.ends

.subckt nmos$1$5 a_n932_n1036# VSUB a_n906_n1000# a_n1000_n1000#
X0 a_n906_n1000# a_n932_n1036# a_n1000_n1000# VSUB sg13_lv_nmos ad=0.34p pd=2.68u as=0.34p ps=2.68u w=1u l=0.13u
C0 a_n906_n1000# a_n1000_n1000# 0.09917f
C1 a_n906_n1000# VSUB 0.05452f
C2 a_n1000_n1000# VSUB 0.05452f
C3 a_n932_n1036# VSUB 0.14818f
.ends

.subckt edge_detector IN OUT VDD VSS
Xpmos$1$10_0 a_2116_557# VSS OUT VDD VDD pmos$1$10
Xpmos$1$10_1 a_2050_461# VSS a_2116_557# VDD VDD pmos$1$10
Xpmos$1$9_0 a_1546_468# a_2050_461# VSS VDD VDD pmos$1$9
Xpmos$1$10_2 IN VSS a_2116_557# VDD VDD pmos$1$10
Xnmos$5_0 a_1546_468# a_2050_461# VSS VSS nmos$5
Xpmos$1$8_0 a_1208_465# a_1546_468# VSS VDD VDD pmos$1$8
Xpmos$1$8_1 a_870_467# a_1208_465# VSS VDD VDD pmos$1$8
Xpmos$1$8_2 a_532_468# a_870_467# VSS VDD VDD pmos$1$8
Xpmos$1$8_3 IN a_532_468# VSS VDD VDD pmos$1$8
Xnmos$4_0 a_1208_465# a_1546_468# VSS VSS nmos$4
Xnmos$1$5_0 a_2050_461# VSS VSS nmos$1$5_2/a_n1000_n1000# nmos$1$5
Xnmos$4_1 a_870_467# a_1208_465# VSS VSS nmos$4
Xnmos$1$5_1 a_2116_557# VSS VSS OUT nmos$1$5
Xnmos$1$5_2 IN VSS a_2116_557# nmos$1$5_2/a_n1000_n1000# nmos$1$5
Xnmos$4_2 a_532_468# a_870_467# VSS VSS nmos$4
Xnmos$4_3 IN a_532_468# VSS VSS nmos$4
C0 a_1546_468# a_1208_465# 0.10815f
C1 OUT a_2116_557# 0.09644f
C2 VDD a_2116_557# 0.15322f
C3 a_1208_465# VDD 0.27444f
C4 IN a_2116_557# 0.11595f
C5 IN a_1208_465# 0.2185f
C6 a_1546_468# VDD 0.27462f
C7 OUT VDD 0.03644f
C8 a_1546_468# IN 0.22768f
C9 OUT IN 0.01233f
C10 a_870_467# a_1208_465# 0.10856f
C11 IN VDD 0.13792f
C12 a_2050_461# a_2116_557# 0.52252f
C13 a_870_467# VDD 0.27463f
C14 a_1546_468# a_2050_461# 0.08756f
C15 a_870_467# IN 0.21231f
C16 OUT a_2050_461# 0.02867f
C17 a_2050_461# VDD 0.19228f
C18 a_2050_461# IN 0.33257f
C19 IN nmos$1$5_2/a_n1000_n1000# 0.03985f
C20 a_532_468# VDD 0.27461f
C21 a_532_468# IN 0.29937f
C22 a_532_468# a_870_467# 0.10874f
C23 a_870_467# VSS 0.77225f
C24 a_2116_557# VSS 0.56248f
C25 OUT VSS 0.21776f
C26 nmos$1$5_2/a_n1000_n1000# VSS 0.03321f
C27 a_1546_468# VSS 0.77213f
C28 a_532_468# VSS 0.79247f
C29 IN VSS 1.47281f
C30 VDD VSS 0.45045f
C31 a_1208_465# VSS 0.77243f
C32 a_2050_461# VSS 0.51177f
.ends
