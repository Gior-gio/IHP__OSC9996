** sch_path: /foss/designs/chipathon_2025/designs/ihp-sg13g2_playground/test_2_integrator_curstav_inv/xschem/test_2_integrator_curstav_inv.sch
.subckt test_2_integrator_curstav_inv

x1 VDD VcrtP out vout1 VcrtN VSS net4 integrator_curstav_inv
V1 VDD GND {VDD}
V2 VSS GND 0
x2 VDD VcrtP vout1 vout2 VcrtN VSS net5 integrator_curstav_inv
x3 VDD VcrtP vout2 vout3 VcrtN VSS net6 integrator_curstav_inv
V3 VcrtN GND {vcontrol}
x4 VDD VcrtP vout3 vout4 VcrtN VSS net7 integrator_curstav_inv
x5 VDD VcrtP vout4 out VcrtN VSS net8 integrator_curstav_inv
* noconn #net1
* noconn #net2
* noconn #net3
M4 VcrtP VcrtP VDD VDD sg13_lv_pmos w=2u l=0.13u ng=1 m=2
M1 VcrtP VcrtN VSS VSS sg13_lv_nmos w=1.0u l=0.13u ng=1 m=2
x6 VDD net1 vout1 out VSS gate_xor
x7 VDD net2 vout3 vout2 VSS gate_xor
x8 VDD net3 out vout4 VSS gate_xor
**** begin user architecture code

.lib cornerMOSlv.lib mos_tt

.TRAN 0.01n 1u
.param vcontrol = 1
.param v_start_stop = 0
.param cap=20u
.param VDD=1.5
.save v(out)

.control

**************************************************
*            PARÁMETROS GENERALES
**************************************************
let VP    = 1.8
let per50 = VP * 0.5

**************************************************
*     PARÁMETROS PARA EL BARRIDO DE vcontrol
*           (con w = 1u fijo)
**************************************************
let vstart   = 0
let vend     = VP
let vstep    = 0.083
let npoints  = (vend - vstart)/vstep + 1

let vpp      = vector(npoints)
let v        = vstart
let idx      = 0

* Crear vectores para almacenar resultados del barrido
let vcontrol_vec = vector(npoints)
let freq_vec     = vector(npoints)

settype voltage   vcontrol_vec
settype frequency freq_vec

alterparam w = 1u

**************************************************
*               BARRIDO DE vcontrol
**************************************************
while v le vend
    alterparam vcontrol = $&v
    reset
    tran 0.1n 0.8u

    meas TRAN T_period TRIG v(out) VAL=per50 rise=2 TARG v(out) VAL=per50 rise=3

    let F_recu             = 1 / T_period
    let vcontrol_vec[idx]  = v
    let freq_vec[idx]      = F_recu
    let vpp[idx]           = $v(vp)

    let v   = v + vstep
    let idx = idx + 1
end

**************************************************
*                  GRÁFICAS
**************************************************
plot freq_vec vs vcontrol_vec

print vcontrol_vec freq_vec vpp

.endc

**** end user architecture code
.ends

* expanding   symbol:  /foss/designs/chipathon_2025/designs/ihp-sg13g2/integrator_curstav_inv/xschem/integrator_curstav_inv.sym #
*+ of pins=7
** sym_path: /foss/designs/chipathon_2025/designs/ihp-sg13g2/integrator_curstav_inv/xschem/integrator_curstav_inv.sym
** sch_path: /foss/designs/chipathon_2025/designs/ihp-sg13g2/integrator_curstav_inv/xschem/integrator_curstav_inv.sch
.subckt integrator_curstav_inv VDD VcrtP A B VcrtN VSS RST
*.PININFO VDD:I VSS:I A:I B:O VcrtP:I VcrtN:I RST:I
M1 B A net2 VSS sg13_lv_nmos w=1.0u l=0.13u ng=1 m=1
M2 net2 VcrtN VSS VSS sg13_lv_nmos w=1.0u l=0.13u ng=1 m=1
M3 B A net1 VDD sg13_lv_pmos w=2u l=0.13u ng=1 m=1
M4 net1 VcrtP VDD VDD sg13_lv_pmos w=2u l=0.13u ng=1 m=1
M5 B VDD VDD VDD sg13_lv_pmos w=2u l=0.13u ng=1 m=1
M6 B RST VSS VSS sg13_lv_nmos w=1.0u l=0.13u ng=1 m=1
.ends

* expanding   symbol:  /foss/designs/chipathon_2025/designs/ihp-sg13g2/gate_xor/xschem/gate_xor.sym # of pins=5
** sym_path: /foss/designs/chipathon_2025/designs/ihp-sg13g2/gate_xor/xschem/gate_xor.sym
** sch_path: /foss/designs/chipathon_2025/designs/ihp-sg13g2/gate_xor/xschem/gate_xor.sch
.subckt gate_xor VDD S B A VSS
*.PININFO VSS:I B:I A:I VDD:I S:O
M2 net1 A VDD VDD sg13_lv_pmos w=2u l=0.13u ng=1 m=1
M1 S -B net1 VDD sg13_lv_pmos w=2u l=0.13u ng=1 m=1
M4 net2 -A VDD VDD sg13_lv_pmos w=2u l=0.13u ng=1 m=1
M5 S B net2 VDD sg13_lv_pmos w=2u l=0.13u ng=1 m=1
M6 S B net4 VSS sg13_lv_nmos w=1.0u l=0.13u ng=1 m=1
M3 net4 A VSS VSS sg13_lv_nmos w=1.0u l=0.13u ng=1 m=1
M7 S -B net3 VSS sg13_lv_nmos w=1.0u l=0.13u ng=1 m=1
M8 net3 -A VSS VSS sg13_lv_nmos w=1.0u l=0.13u ng=1 m=1
x3 VDD A -A VSS gate_inv_L0d13
x1 VDD B -B VSS gate_inv_L0d13
.ends

* expanding   symbol:  /foss/designs/chipathon_2025/designs/ihp-sg13g2/gate_inv_L0d13/xschem/gate_inv_L0d13.sym # of pins=4
** sym_path: /foss/designs/chipathon_2025/designs/ihp-sg13g2/gate_inv_L0d13/xschem/gate_inv_L0d13.sym
** sch_path: /foss/designs/chipathon_2025/designs/ihp-sg13g2/gate_inv_L0d13/xschem/gate_inv_L0d13.sch
.subckt gate_inv_L0d13 VDD VIN VOUT VSS
*.PININFO VDD:I VSS:I VIN:I VOUT:O
M2 VOUT VIN VDD VDD sg13_lv_pmos w=2u l=0.13u ng=1 m=1
M1 VOUT VIN VSS VSS sg13_lv_nmos w=1.0u l=0.13u ng=1 m=1
.ends

.GLOBAL GND
