* NGSPICE file created from integrator.ext - technology: ihp-sg13g2

.subckt nmos$3$2 a_n932_n1036# VSUB a_n906_n1000# a_n1000_n1000#
X0 a_n906_n1000# a_n932_n1036# a_n1000_n1000# VSUB sg13_lv_nmos ad=0.34p pd=2.68u as=0.34p ps=2.68u w=1u l=0.13u
.ends

.subckt nmos$2 a_n932_n1036# VSUB a_n906_n1000# a_n1000_n1000#
X0 a_n906_n1000# a_n932_n1036# a_n1000_n1000# VSUB sg13_lv_nmos ad=0.34p pd=2.68u as=0.34p ps=2.68u w=1u l=0.13u
.ends

.subckt rppd$7 a_n1000_n1086# a_n1000_n900#
X0 a_n1000_n900# a_n1000_n1086# rppd l=0.5u w=0.5u
.ends

.subckt pmos$3 a_n932_n1036# a_n906_n1000# a_n1000_n1000# w_n1062_n1062#
X0 a_n906_n1000# a_n932_n1036# a_n1000_n1000# w_n1062_n1062# sg13_lv_pmos ad=0.68p pd=4.68u as=0.68p ps=4.68u w=2u l=0.13u
.ends

.subckt rppd a_n1000_n1086# a_n1000_n900#
X0 a_n1000_n900# a_n1000_n1086# rppd l=0.5u w=0.5u
.ends

.subckt pmos$2$7 a_n932_n1036# a_n906_n1000# a_n1000_n1000# w_n1062_n1062#
X0 a_n906_n1000# a_n932_n1036# a_n1000_n1000# w_n1062_n1062# sg13_lv_pmos ad=0.68p pd=4.68u as=0.68p ps=4.68u w=2u l=0.13u
.ends

.subckt pmos$5$7 a_n932_n1036# a_n906_n1000# a_n1000_n1000# w_n1062_n1062#
X0 a_n906_n1000# a_n932_n1036# a_n1000_n1000# w_n1062_n1062# sg13_lv_pmos ad=0.68p pd=4.68u as=0.68p ps=4.68u w=2u l=0.13u
.ends

.subckt nmos$1$3$1 a_2094_n1000# a_2068_n1036# VSUB a_2000_n1000#
X0 a_2094_n1000# a_2068_n1036# a_2000_n1000# VSUB sg13_lv_nmos ad=0.34p pd=2.68u as=0.34p ps=2.68u w=1u l=0.13u
.ends

.subckt nmos$1$3$1$7 a_2094_n1000# a_2068_n1036# VSUB a_2000_n1000#
X0 a_2094_n1000# a_2068_n1036# a_2000_n1000# VSUB sg13_lv_nmos ad=0.34p pd=2.68u as=0.34p ps=2.68u w=1u l=0.13u
.ends

.subckt nmos$3$9 a_n932_n1036# VSUB a_n906_n1000# a_n1000_n1000#
X0 a_n906_n1000# a_n932_n1036# a_n1000_n1000# VSUB sg13_lv_nmos ad=0.34p pd=2.68u as=0.34p ps=2.68u w=1u l=0.13u
.ends

.subckt pmos$4$1$7 a_2094_n1000# w_1938_n1062# a_2068_n1036# a_2000_n1000#
X0 a_2094_n1000# a_2068_n1036# a_2000_n1000# w_1938_n1062# sg13_lv_pmos ad=0.68p pd=4.68u as=0.68p ps=4.68u w=2u l=0.13u
.ends

.subckt pmos$4 a_2094_n1000# w_1938_n1062# a_2068_n1036# a_2000_n1000#
X0 a_2094_n1000# a_2068_n1036# a_2000_n1000# w_1938_n1062# sg13_lv_pmos ad=0.68p pd=4.68u as=0.68p ps=4.68u w=2u l=0.13u
.ends

.subckt nmos$1$3$8 a_2094_n1000# a_2068_n1036# VSUB a_2000_n1000#
X0 a_2094_n1000# a_2068_n1036# a_2000_n1000# VSUB sg13_lv_nmos ad=0.34p pd=2.68u as=0.34p ps=2.68u w=1u l=0.13u
.ends

.subckt pmos$2 a_n932_n1036# a_n906_n1000# a_n1000_n1000# w_n1062_n1062#
X0 a_n906_n1000# a_n932_n1036# a_n1000_n1000# w_n1062_n1062# sg13_lv_pmos ad=0.68p pd=4.68u as=0.68p ps=4.68u w=2u l=0.13u
.ends

.subckt nmos$3 a_n932_n1036# VSUB a_n906_n1000# a_n1000_n1000#
X0 a_n906_n1000# a_n932_n1036# a_n1000_n1000# VSUB sg13_lv_nmos ad=0.34p pd=2.68u as=0.34p ps=2.68u w=1u l=0.13u
.ends

.subckt nmos$2$7 a_n932_n1036# VSUB a_n906_n1000# a_n1000_n1000#
X0 a_n906_n1000# a_n932_n1036# a_n1000_n1000# VSUB sg13_lv_nmos ad=0.34p pd=2.68u as=0.34p ps=2.68u w=1u l=0.13u
.ends

.subckt pmos$4$1 a_2094_n1000# w_1938_n1062# a_2068_n1036# a_2000_n1000#
X0 a_2094_n1000# a_2068_n1036# a_2000_n1000# w_1938_n1062# sg13_lv_pmos ad=0.68p pd=4.68u as=0.68p ps=4.68u w=2u l=0.13u
.ends

.subckt pmos$5 a_n932_n1036# a_n906_n1000# a_n1000_n1000# w_n1062_n1062#
X0 a_n906_n1000# a_n932_n1036# a_n1000_n1000# w_n1062_n1062# sg13_lv_pmos ad=0.68p pd=4.68u as=0.68p ps=4.68u w=2u l=0.13u
.ends

.subckt pmos$4$8 a_2094_n1000# w_1938_n1062# a_2068_n1036# a_2000_n1000#
X0 a_2094_n1000# a_2068_n1036# a_2000_n1000# w_1938_n1062# sg13_lv_pmos ad=0.68p pd=4.68u as=0.68p ps=4.68u w=2u l=0.13u
.ends

.subckt pmos a_68_n36# w_n62_n62# a_94_0# a_0_0#
X0 a_94_0# a_68_n36# a_0_0# w_n62_n62# sg13_lv_pmos ad=0.68p pd=4.68u as=0.68p ps=4.68u w=2u l=0.13u
.ends

.subckt nmos$4 a_68_n36# VSUB a_94_0# a_0_0#
X0 a_94_0# a_68_n36# a_0_0# VSUB sg13_lv_nmos ad=0.34p pd=2.68u as=0.34p ps=2.68u w=1u l=0.13u
.ends

.subckt nmos$1$3 a_2094_n1000# a_2068_n1036# VSUB a_2000_n1000#
X0 a_2094_n1000# a_2068_n1036# a_2000_n1000# VSUB sg13_lv_nmos ad=0.34p pd=2.68u as=0.34p ps=2.68u w=1u l=0.13u
.ends

.subckt integrator Vref VSS VDD RST Vctr VOUT
Xnmos$3$2_5 a_3233_3479# VSS a_3427_3575# VSS nmos$3$2
Xnmos$2_3 a_2307_3567# VSS nmos$2_3/a_n906_n1000# VSS nmos$2
Xrppd$7_15 VSS VSS rppd$7
Xpmos$3_14 VDD VDD a_1343_3470# VDD pmos$3
Xpmos$3_25 a_1343_3470# pmos$3_25/a_n906_n1000# a_2511_3567# VDD pmos$3
Xrppd_9 VSS VSS rppd
Xpmos$2$7_6 a_2511_2653# pmos$2$7_6/a_n906_n1000# a_3233_2741# VDD pmos$2$7
Xpmos$5$7_3 a_3427_2645# m1_3530_2558# VDD VDD pmos$5$7
Xnmos$2_4 a_1915_4786# VSS nmos$2_4/a_n906_n1000# VSS nmos$2
Xnmos$3$2_6 a_3427_1347# VSS VSS m1_3530_1452# nmos$3$2
Xpmos$3_15 VDD VDD a_1343_4786# VDD pmos$3
Xrppd$7_16 VSS VSS rppd$7
Xpmos$5$7_4 a_3233_4969# a_3427_4873# VDD VDD pmos$5$7
Xpmos$3_26 VDD VDD a_2307_3567# VDD pmos$3
Xpmos$2$7_7 a_1343_3470# pmos$2$7_7/a_n906_n1000# a_3233_4969# VDD pmos$2$7
Xnmos$1$3$1_0 a_2842_1435# a_2511_1339# VSS VSS nmos$1$3$1
Xnmos$1$3$1$7_0 a_2842_2557# a_2511_2653# VSS VSS nmos$1$3$1$7
Xnmos$2_5 a_1343_4786# VSS a_3233_5707# nmos$2_4/a_n906_n1000# nmos$2
Xnmos$3$2_7 a_3427_1347# VSS m1_3530_1452# VSS nmos$3$2
Xnmos$3$9_0 a_3427_2645# VSS m1_3530_2558# VSS nmos$3$9
Xpmos$3_16 a_917_3663# VDD pmos$3_17/a_n906_n1000# VDD pmos$3
Xpmos$3_27 a_917_2558# VDD pmos$3_28/a_n906_n1000# VDD pmos$3
Xnmos$2_10 a_2842_5891# VSS nmos$2_10/a_n906_n1000# a_3233_5707# nmos$2
Xrppd$7_17 VSS VSS rppd$7
Xnmos$1$3$1$7_1 a_2842_4785# a_1343_3470# VSS VSS nmos$1$3$1$7
Xpmos$5$7_5 a_3427_4873# VDD m1_3530_4786# VDD pmos$5$7
Xnmos$1$3$1_1 a_2842_3663# a_2511_3567# VSS VSS nmos$1$3$1
Xnmos$3$9_1 a_3427_2645# VSS VSS m1_3530_2558# nmos$3$9
Xnmos$3$2_8 a_3233_5707# VSS a_3427_5803# VSS nmos$3$2
Xnmos$2_6 a_3085_1244# VSS VSS nmos$2_7/a_n906_n1000# nmos$2
Xpmos$3_17 a_2511_1339# pmos$3_17/a_n906_n1000# a_1343_4786# VDD pmos$3
Xrppd$7_18 VSS VSS rppd$7
Xpmos$5$7_6 a_3427_4873# m1_3530_4786# VDD VDD pmos$5$7
Xpmos$3_28 a_1915_3470# pmos$3_28/a_n906_n1000# a_2307_3567# VDD pmos$3
Xnmos$2_11 a_3085_5700# VSS VSS nmos$2_10/a_n906_n1000# nmos$2
Xrppd$7_0 VSS VSS rppd$7
Xnmos$3$2_9 a_3427_5803# VSS m1_3530_5908# VSS nmos$3$2
Xnmos$1$3$1_2 a_2842_5891# a_1343_4786# VSS VSS nmos$1$3$1
Xnmos$2_7 a_2842_1435# VSS nmos$2_7/a_n906_n1000# a_3233_1251# nmos$2
Xpmos$4$1$7_0 a_2842_2557# VDD a_2511_2653# VDD pmos$4$1$7
Xnmos$3$9_2 a_3427_2645# VSS m1_3530_2558# VSS nmos$3$9
Xpmos$3_18 VDD VDD a_1915_3470# VDD pmos$3
Xpmos$3_29 VDD VDD a_2511_3567# VDD pmos$3
Xrppd$7_19 m1_3530_4786# VOUT rppd$7
Xpmos$5$7_7 a_3427_4873# m1_3530_4786# VDD VDD pmos$5$7
Xrppd$7_1 m1_3530_2558# VOUT rppd$7
Xpmos$4$1$7_1 a_2842_4785# VDD a_1343_3470# VDD pmos$4$1$7
Xnmos$2_8 a_3085_3472# VSS VSS nmos$2_9/a_n906_n1000# nmos$2
Xnmos$3$9_3 a_3233_2741# VSS a_3427_2645# VSS nmos$3$9
Xpmos$3_19 a_1915_4786# pmos$3_19/a_n906_n1000# a_1915_3470# VDD pmos$3
Xrppd$7_2 VSS VSS rppd$7
Xnmos$3$9_4 a_3427_4873# VSS m1_3530_4786# VSS nmos$3$9
Xnmos$2_9 a_2842_3663# VSS nmos$2_9/a_n906_n1000# a_3233_3479# nmos$2
Xrppd$7_3 m1_3530_2558# VOUT rppd$7
Xrppd_30 m1_3530_5908# VOUT rppd
Xpmos$4_0 a_3085_1244# VDD a_2307_1339# VDD pmos$4
Xnmos$3$9_5 a_3427_4873# VSS VSS m1_3530_4786# nmos$3$9
Xpmos$4_1 a_3085_5700# VDD a_1915_4786# VDD pmos$4
Xrppd$7_4 VSS VSS rppd$7
Xrppd_20 VSS VSS rppd
Xrppd_31 VSS VSS rppd
Xnmos$3$9_6 a_3427_4873# VSS m1_3530_4786# VSS nmos$3$9
Xrppd$7_5 VSS VSS rppd$7
Xrppd_32 VSS VSS rppd
Xrppd_21 VSS VSS rppd
Xpmos$4_2 a_3085_3472# VDD a_2307_3567# VDD pmos$4
Xrppd_10 m1_3530_3680# VOUT rppd
Xnmos$1$3$8_0 a_3085_2558# a_1915_1242# VSS VSS nmos$1$3$8
Xnmos$3$9_7 a_3233_4969# VSS a_3427_4873# VSS nmos$3$9
Xnmos$1$3$8_1 a_3085_4786# a_1915_3470# VSS VSS nmos$1$3$8
Xrppd$7_6 VSS VSS rppd$7
Xrppd_33 VSS VSS rppd
Xrppd_22 VSS VSS rppd
Xpmos$2_0 a_2307_1339# pmos$2_0/a_n906_n1000# VDD VDD pmos$2
Xrppd_11 VSS VSS rppd
Xrppd$7_7 VSS VSS rppd$7
Xrppd_34 VSS VSS rppd
Xrppd_23 VSS VSS rppd
Xrppd_12 VSS VSS rppd
Xpmos$2_1 a_2842_1435# a_3233_1251# pmos$2_0/a_n906_n1000# VDD pmos$2
Xrppd$7_8 VSS VSS rppd$7
Xrppd_35 VSS VSS rppd
Xpmos$2_2 a_2842_5891# a_3233_5707# pmos$2_3/a_n906_n1000# VDD pmos$2
Xrppd_24 VSS VSS rppd
Xrppd_13 m1_3530_1452# VOUT rppd
Xrppd$7_9 VSS VSS rppd$7
Xrppd_25 VSS VSS rppd
Xrppd_14 VSS VSS rppd
Xpmos$2_3 a_1915_4786# pmos$2_3/a_n906_n1000# VDD VDD pmos$2
Xnmos$3_0 Vref VSS VSS nmos$3_16/a_n906_n1000# nmos$3
Xnmos$3_20 RST VSS VSS a_1915_4786# nmos$3
Xrppd_26 m1_3530_3680# VOUT rppd
Xrppd_15 VSS VSS rppd
Xpmos$2_4 a_3085_1244# VDD pmos$2_4/a_n1000_n1000# VDD pmos$2
Xnmos$3_1 a_2511_2653# VSS nmos$3_1/a_n906_n1000# a_2511_1339# nmos$3
Xnmos$3_21 RST VSS VSS a_1343_4786# nmos$3
Xnmos$3_10 a_2511_3567# VSS nmos$3_9/a_n1000_n1000# a_2511_2653# nmos$3
Xrppd_27 VSS VSS rppd
Xpmos$2_5 a_3085_5700# VDD pmos$2_5/a_n1000_n1000# VDD pmos$2
Xrppd_16 m1_3530_1452# VOUT rppd
Xnmos$3_2 RST VSS VSS a_2307_1339# nmos$3
Xrppd_28 m1_3530_5908# VOUT rppd
Xnmos$3_22 Vref VSS VSS nmos$3_25/a_n906_n1000# nmos$3
Xpmos$2_6 a_3085_3472# VDD pmos$2_8/a_n906_n1000# VDD pmos$2
Xrppd_17 VSS VSS rppd
Xnmos$3_11 VSS VSS VSS a_1915_1242# nmos$3
Xnmos$2$7_0 a_1915_1242# VSS nmos$2$7_0/a_n906_n1000# VSS nmos$2$7
Xnmos$3_3 Vctr VSS VSS nmos$3_1/a_n906_n1000# nmos$3
Xrppd_18 VSS VSS rppd
Xrppd_29 VSS VSS rppd
Xnmos$3_23 a_1915_4786# VSS nmos$3_23/a_n906_n1000# a_1915_3470# nmos$3
Xpmos$2_7 a_2307_3567# pmos$2_7/a_n906_n1000# VDD VDD pmos$2
Xnmos$3_12 RST VSS VSS a_2307_3567# nmos$3
Xnmos$2$7_1 a_2511_2653# VSS a_3233_2741# nmos$2$7_0/a_n906_n1000# nmos$2$7
Xnmos$3_4 RST VSS VSS a_2511_1339# nmos$3
Xrppd_19 VSS VSS rppd
Xnmos$3_24 Vref VSS VSS nmos$3_23/a_n906_n1000# nmos$3
Xnmos$3_13 Vref VSS VSS nmos$3_17/a_n906_n1000# nmos$3
Xpmos$2_8 a_2511_3567# pmos$2_8/a_n906_n1000# a_3233_3479# VDD pmos$2
Xpmos$4$1_0 a_2842_1435# VDD a_2511_1339# VDD pmos$4$1
Xnmos$2$7_2 a_1343_3470# VSS a_3233_4969# nmos$2$7_3/a_n906_n1000# nmos$2$7
Xnmos$3_5 Vctr VSS VSS nmos$3_8/a_n906_n1000# nmos$3
Xnmos$3_25 a_2307_1339# VSS nmos$3_25/a_n906_n1000# a_1915_4786# nmos$3
Xpmos$2_9 a_2842_3663# a_3233_3479# pmos$2_7/a_n906_n1000# VDD pmos$2
Xnmos$3_14 Vref VSS VSS nmos$3_15/a_n906_n1000# nmos$3
Xpmos$4$1_1 a_2842_5891# VDD a_1343_4786# VDD pmos$4$1
Xnmos$2$7_3 a_1915_3470# VSS nmos$2$7_3/a_n906_n1000# VSS nmos$2$7
Xnmos$3_6 VSS VSS VSS a_2511_2653# nmos$3
Xnmos$3_26 Vctr VSS VSS nmos$3_27/a_n906_n1000# nmos$3
Xnmos$3_15 a_1915_3470# VSS nmos$3_15/a_n906_n1000# a_2307_3567# nmos$3
Xpmos$4$1_2 a_2842_3663# VDD a_2511_3567# VDD pmos$4$1
Xpmos$2_10 a_2511_1339# pmos$2_4/a_n1000_n1000# a_3233_1251# VDD pmos$2
Xnmos$2$7_4 a_3085_2558# VSS VSS nmos$2$7_5/a_n906_n1000# nmos$2$7
Xnmos$3_7 RST VSS VSS a_2511_3567# nmos$3
Xnmos$3_27 a_1343_4786# VSS nmos$3_27/a_n906_n1000# a_1343_3470# nmos$3
Xpmos$5_10 a_3427_3575# VDD m1_3530_3680# VDD pmos$5
Xnmos$3_16 a_1915_1242# VSS nmos$3_16/a_n906_n1000# a_2307_1339# nmos$3
Xpmos$2_11 a_1343_4786# pmos$2_5/a_n1000_n1000# a_3233_5707# VDD pmos$2
Xnmos$2$7_5 a_2842_2557# VSS nmos$2$7_5/a_n906_n1000# a_3233_2741# nmos$2$7
Xnmos$3_8 a_1343_3470# VSS nmos$3_8/a_n906_n1000# a_2511_3567# nmos$3
Xnmos$3_28 VSS VSS VSS a_1343_3470# nmos$3
Xpmos$5_11 a_3427_3575# m1_3530_3680# VDD VDD pmos$5
Xnmos$3_17 a_2307_3567# VSS nmos$3_17/a_n906_n1000# a_1915_1242# nmos$3
Xnmos$2$7_6 a_2842_4785# VSS nmos$2$7_6/a_n906_n1000# a_3233_4969# nmos$2$7
Xnmos$3_9 Vctr VSS VSS nmos$3_9/a_n1000_n1000# nmos$3
Xnmos$3_18 Vctr VSS VSS nmos$3_19/a_n906_n1000# nmos$3
Xnmos$3_29 VSS VSS VSS a_1915_3470# nmos$3
Xnmos$2$7_7 a_3085_4786# VSS VSS nmos$2$7_6/a_n906_n1000# nmos$2$7
Xpmos$5_0 a_3427_1347# m1_3530_1452# VDD VDD pmos$5
Xnmos$3_19 a_2511_1339# VSS nmos$3_19/a_n906_n1000# a_1343_4786# nmos$3
Xpmos$5_1 a_3233_1251# a_3427_1347# VDD VDD pmos$5
Xpmos$5_2 a_3427_1347# VDD m1_3530_1452# VDD pmos$5
Xpmos$4$8_0 a_3085_2558# VDD a_1915_1242# VDD pmos$4$8
Xpmos$4$8_1 a_3085_4786# VDD a_1915_3470# VDD pmos$4$8
Xpmos$5_3 a_3427_1347# m1_3530_1452# VDD VDD pmos$5
Xpmos$3_0 a_917_3663# VDD pmos$3_1/a_n906_n1000# VDD pmos$3
Xpmos$5_4 a_3233_5707# a_3427_5803# VDD VDD pmos$5
Xpmos$3_1 a_2511_2653# pmos$3_1/a_n906_n1000# a_2511_1339# VDD pmos$3
Xrppd_0 VSS VSS rppd
Xpmos$5_5 a_3427_5803# m1_3530_5908# VDD VDD pmos$5
Xpmos$3_2 VDD VDD a_2511_1339# VDD pmos$3
Xrppd_1 VSS VSS rppd
Xpmos_0 a_917_2558# VDD a_917_2558# VDD pmos
Xpmos$5_6 a_3427_5803# m1_3530_5908# VDD VDD pmos$5
Xpmos$3_3 a_917_2558# VDD pmos$3_3/a_n1000_n1000# VDD pmos$3
Xrppd_2 VSS VSS rppd
Xpmos_1 a_917_3663# VDD a_917_3663# VDD pmos
Xnmos$4_0 Vctr VSS a_917_3663# VSS nmos$4
Xpmos$5_7 a_3427_5803# VDD m1_3530_5908# VDD pmos$5
Xrppd$7_20 VSS VSS rppd$7
Xrppd_3 VSS VSS rppd
Xpmos$3_4 VDD VDD a_1915_1242# VDD pmos$3
Xpmos$2$7_0 a_1915_1242# pmos$2$7_0/a_n906_n1000# VDD VDD pmos$2$7
Xnmos$3$2_0 a_3427_3575# VSS m1_3530_3680# VSS nmos$3$2
Xnmos$4_1 Vref VSS a_917_2558# VSS nmos$4
Xpmos$3_20 a_917_2558# VDD pmos$3_19/a_n906_n1000# VDD pmos$3
Xpmos$5_8 a_3427_3575# m1_3530_3680# VDD VDD pmos$5
Xpmos$3_5 VDD VDD a_2511_2653# VDD pmos$3
Xrppd$7_21 m1_3530_4786# VOUT rppd$7
Xrppd_4 VSS VSS rppd
Xpmos$2$7_1 a_2842_2557# a_3233_2741# pmos$2$7_0/a_n906_n1000# VDD pmos$2$7
Xrppd$7_10 VSS VSS rppd$7
Xpmos$5_9 a_3233_3479# a_3427_3575# VDD VDD pmos$5
Xnmos$3$2_1 a_3427_3575# VSS VSS m1_3530_3680# nmos$3$2
Xpmos$3_21 a_917_2558# VDD pmos$3_22/a_n906_n1000# VDD pmos$3
Xrppd$7_22 VSS VSS rppd$7
Xpmos$3_6 VDD VDD a_2307_1339# VDD pmos$3
Xpmos$3_10 a_2307_3567# pmos$3_3/a_n1000_n1000# a_1915_1242# VDD pmos$3
Xrppd$7_11 VSS VSS rppd$7
Xpmos$2$7_2 a_1915_3470# pmos$2$7_2/a_n906_n1000# VDD VDD pmos$2$7
Xrppd_5 VSS VSS rppd
Xpmos$3_22 a_2307_1339# pmos$3_22/a_n906_n1000# a_1915_4786# VDD pmos$3
Xnmos$3$2_2 a_3427_3575# VSS m1_3530_3680# VSS nmos$3$2
Xpmos$3_11 a_917_2558# VDD pmos$3_7/a_n906_n1000# VDD pmos$3
Xpmos$3_7 a_1915_1242# pmos$3_7/a_n906_n1000# a_2307_1339# VDD pmos$3
Xnmos$2_0 a_2511_1339# VSS a_3233_1251# nmos$2_1/a_n906_n1000# nmos$2
Xrppd$7_23 VSS VSS rppd$7
Xrppd$7_12 VSS VSS rppd$7
Xrppd_6 VSS VSS rppd
Xnmos$1$3_0 a_3085_1244# a_2307_1339# VSS VSS nmos$1$3
Xpmos$5$7_0 a_3427_2645# m1_3530_2558# VDD VDD pmos$5$7
Xpmos$2$7_3 a_2842_4785# a_3233_4969# pmos$2$7_2/a_n906_n1000# VDD pmos$2$7
Xnmos$2_1 a_2307_1339# VSS nmos$2_1/a_n906_n1000# VSS nmos$2
Xnmos$3$2_3 a_3233_1251# VSS a_3427_1347# VSS nmos$3$2
Xpmos$3_23 VDD VDD a_1915_4786# VDD pmos$3
Xrppd$7_13 VSS VSS rppd$7
Xpmos$3_12 a_917_3663# VDD pmos$3_13/a_n906_n1000# VDD pmos$3
Xpmos$3_8 a_917_3663# VDD pmos$3_9/a_n906_n1000# VDD pmos$3
Xnmos$3$2_10 a_3427_5803# VSS VSS m1_3530_5908# nmos$3$2
Xrppd_7 VSS VSS rppd
Xnmos$1$3_1 a_3085_3472# a_2307_3567# VSS VSS nmos$1$3
Xpmos$2$7_4 a_3085_2558# VDD pmos$2$7_6/a_n906_n1000# VDD pmos$2$7
Xpmos$5$7_1 a_3427_2645# VDD m1_3530_2558# VDD pmos$5$7
Xnmos$2_2 a_2511_3567# VSS a_3233_3479# nmos$2_3/a_n906_n1000# nmos$2
Xnmos$3$2_4 a_3427_1347# VSS m1_3530_1452# VSS nmos$3$2
Xpmos$3_9 a_2511_3567# pmos$3_9/a_n906_n1000# a_2511_2653# VDD pmos$3
Xnmos$3$2_11 a_3427_5803# VSS m1_3530_5908# VSS nmos$3$2
Xnmos$1$3_2 a_3085_5700# a_1915_4786# VSS VSS nmos$1$3
Xrppd$7_14 VSS VSS rppd$7
Xpmos$3_13 a_1343_4786# pmos$3_13/a_n906_n1000# a_1343_3470# VDD pmos$3
Xpmos$3_24 a_917_3663# VDD pmos$3_25/a_n906_n1000# VDD pmos$3
Xrppd_8 VSS VSS rppd
Xpmos$5$7_2 a_3233_2741# a_3427_2645# VDD VDD pmos$5$7
Xpmos$2$7_5 a_3085_4786# VDD pmos$2$7_7/a_n906_n1000# VDD pmos$2$7
.ends
