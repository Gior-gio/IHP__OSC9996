* NGSPICE file created from integrator.ext - technology: ihp-sg13g2

.subckt integrator Vref VSS VDD RST Vctr VOUT
X0 VSS.t188 VSS.t189 VSS rppd l=0.5u w=0.5u
X1 a_2584_2122# a_1267_2122# VDD.t48 VDD.t3 sg13_lv_pmos ad=0.68p pd=4.68u as=0.68p ps=4.68u w=2u l=0.13u
X2 a_3521_3236# VOUT.t6 VSS rppd l=0.5u w=0.5u
X3 a_1941_5986# a_1839_1008.t2 a_1839_5464# VDD.t6 sg13_lv_pmos ad=0.38p pd=2.38u as=0.38p ps=2.38u w=2u l=0.13u
X4 a_3521_1008# a_3317_1008# VDD.t44 VDD.t3 sg13_lv_pmos ad=0.68p pd=4.68u as=0.38p ps=2.38u w=2u l=0.13u
X5 a_917_2086.t2 a_917_2086.t1 VDD.t9 VDD.t3 sg13_lv_pmos ad=0.68p pd=4.68u as=0.68p ps=4.68u w=2u l=0.13u
X6 VSS.t122 VSS.t123 VSS rppd l=0.5u w=0.5u
X7 a_1369_2844# a_1267_3236# a_1267_2122# VSS.t49 sg13_lv_nmos ad=0.19p pd=1.38u as=0.19p ps=1.38u w=1u l=0.13u
X8 VSS.t80 Vctr.t0 a_1369_5072# VSS.t71 sg13_lv_nmos ad=0.34p pd=2.68u as=0.19p ps=1.38u w=1u l=0.13u
X9 a_2907_2122# a_1267_2122# a_2805_2844# VSS.t46 sg13_lv_nmos ad=0.19p pd=1.38u as=0.19p ps=1.38u w=1u l=0.13u
X10 a_2805_5464# a_1839_5464# VSS.t131 VSS.t51 sg13_lv_nmos ad=0.19p pd=1.38u as=0.34p ps=2.68u w=1u l=0.13u
X11 a_3009_5072# a_2584_4350# a_2907_4350# VSS.t79 sg13_lv_nmos ad=0.19p pd=1.38u as=0.19p ps=1.38u w=1u l=0.13u
X12 a_1941_1008# a_1839_2122# a_1839_1008.t0 VSS.t112 sg13_lv_nmos ad=0.19p pd=1.38u as=0.19p ps=1.38u w=1u l=0.13u
X13 a_3317_1008# a_2907_1008# VDD.t4 VDD.t3 sg13_lv_pmos ad=0.68p pd=4.68u as=0.68p ps=4.68u w=2u l=0.13u
X14 VSS.t60 Vref.t0 a_1941_5464# VSS.t59 sg13_lv_nmos ad=0.34p pd=2.68u as=0.19p ps=1.38u w=1u l=0.13u
X15 VSS.t75 VSS.t76 VSS rppd l=0.5u w=0.5u
X16 a_1839_3236# VDD.t71 VDD.t72 VDD.t0 sg13_lv_pmos ad=0.38p pd=2.38u as=0.68p ps=4.68u w=2u l=0.13u
X17 VSS.t133 Vctr.t1 a_1369_3236# VSS.t132 sg13_lv_nmos ad=0.34p pd=2.68u as=0.19p ps=1.38u w=1u l=0.13u
X18 a_1941_2122# a_1839_3236# a_1839_2122# VDD.t3 sg13_lv_pmos ad=0.38p pd=2.38u as=0.38p ps=2.38u w=2u l=0.13u
X19 a_3009_3236# a_2584_3236# a_2907_3236# VSS.t102 sg13_lv_nmos ad=0.19p pd=1.38u as=0.19p ps=1.38u w=1u l=0.13u
X20 a_3521_2122# a_3317_2122# VSS.t205 VSS.t93 sg13_lv_nmos ad=0.34p pd=2.68u as=0.19p ps=1.38u w=1u l=0.13u
X21 a_1369_5986# a_1267_1008.t2 a_1267_5464# VDD.t6 sg13_lv_pmos ad=0.38p pd=2.38u as=0.38p ps=2.38u w=2u l=0.13u
X22 VSS.t8 VSS.t9 VSS rppd l=0.5u w=0.5u
X23 VSS.t63 VSS.t64 VSS rppd l=0.5u w=0.5u
X24 a_2907_5464# a_2584_5464# a_2805_5986# VDD.t6 sg13_lv_pmos ad=0.38p pd=2.38u as=0.38p ps=2.38u w=2u l=0.13u
X25 a_3521_5464# a_3317_5464# VSS.t109 VSS.t108 sg13_lv_nmos ad=0.19p pd=1.38u as=0.34p ps=2.68u w=1u l=0.13u
X26 VDD.t36 a_917_3663.t3 a_1369_4350# VDD.t0 sg13_lv_pmos ad=0.68p pd=4.68u as=0.38p ps=2.38u w=2u l=0.13u
X27 a_3317_2122# a_2907_2122# VSS.t29 VSS.t2 sg13_lv_nmos ad=0.34p pd=2.68u as=0.34p ps=2.68u w=1u l=0.13u
X28 VSS.t44 VSS.t45 VSS rppd l=0.5u w=0.5u
X29 a_3009_4350# a_1267_4350# a_2907_4350# VDD.t0 sg13_lv_pmos ad=0.38p pd=2.38u as=0.38p ps=2.38u w=2u l=0.13u
X30 a_1369_1008# a_1267_2122# a_1267_1008.t0 VSS.t203 sg13_lv_nmos ad=0.19p pd=1.38u as=0.19p ps=1.38u w=1u l=0.13u
X31 a_2907_1008# a_1267_1008.t3 a_2805_1008# VSS.t65 sg13_lv_nmos ad=0.19p pd=1.38u as=0.19p ps=1.38u w=1u l=0.13u
X32 VSS.t113 VSS.t114 VSS rppd l=0.5u w=0.5u
X33 a_1267_3236# VDD.t69 VDD.t70 VDD.t0 sg13_lv_pmos ad=0.38p pd=2.38u as=0.68p ps=4.68u w=2u l=0.13u
X34 a_2380_4350# a_1839_4350# VSS.t54 VSS.t53 sg13_lv_nmos ad=0.34p pd=2.68u as=0.34p ps=2.68u w=1u l=0.13u
X35 a_3521_5464# a_3317_5464# VDD.t27 VDD.t6 sg13_lv_pmos ad=0.68p pd=4.68u as=0.38p ps=2.38u w=2u l=0.13u
X36 a_1369_2122# a_1267_3236# a_1267_2122# VDD.t3 sg13_lv_pmos ad=0.38p pd=2.38u as=0.38p ps=2.38u w=2u l=0.13u
X37 VSS.t162 VSS.t163 VSS rppd l=0.5u w=0.5u
X38 a_2907_2122# a_2584_2122# a_2805_2122# VDD.t3 sg13_lv_pmos ad=0.38p pd=2.38u as=0.38p ps=2.38u w=2u l=0.13u
X39 a_3317_5464# a_2907_5464# VDD.t20 VDD.t6 sg13_lv_pmos ad=0.68p pd=4.68u as=0.68p ps=4.68u w=2u l=0.13u
X40 a_3521_1008# a_3317_1008# VSS.t173 VSS.t176 sg13_lv_nmos ad=0.34p pd=2.68u as=0.19p ps=1.38u w=1u l=0.13u
X41 a_2380_3236# a_1839_3236# VSS.t101 VSS.t100 sg13_lv_nmos ad=0.34p pd=2.68u as=0.34p ps=2.68u w=1u l=0.13u
X42 VSS.t4 VSS.t5 VSS rppd l=0.5u w=0.5u
X43 VDD.t22 a_3317_3236# a_3521_3236# VDD.t0 sg13_lv_pmos ad=0.38p pd=2.38u as=0.38p ps=2.38u w=2u l=0.13u
X44 a_3317_1008# a_2907_1008# VSS.t7 VSS.t6 sg13_lv_nmos ad=0.34p pd=2.68u as=0.34p ps=2.68u w=1u l=0.13u
X45 VSS.t119 VSS.t120 VSS rppd l=0.5u w=0.5u
X46 VDD.t5 a_917_3663.t4 a_1369_1530# VDD.t3 sg13_lv_pmos ad=0.68p pd=4.68u as=0.38p ps=2.38u w=2u l=0.13u
X47 a_3521_2122# a_3317_2122# VDD.t50 VDD.t3 sg13_lv_pmos ad=0.68p pd=4.68u as=0.38p ps=2.38u w=2u l=0.13u
X48 a_2380_4350# a_1839_4350# VDD.t16 VDD.t0 sg13_lv_pmos ad=0.68p pd=4.68u as=0.68p ps=4.68u w=2u l=0.13u
X49 VDD.t17 a_2380_3236# a_3009_3758# VDD.t0 sg13_lv_pmos ad=0.68p pd=4.68u as=0.38p ps=2.38u w=2u l=0.13u
X50 a_1839_5464# RST.t0 VSS.t138 VSS.t137 sg13_lv_nmos ad=0.19p pd=1.38u as=0.34p ps=2.68u w=1u l=0.13u
X51 a_2584_3236# a_1267_3236# VDD.t14 VDD.t0 sg13_lv_pmos ad=0.68p pd=4.68u as=0.68p ps=4.68u w=2u l=0.13u
X52 a_3009_1530# a_1267_1008.t4 a_2907_1008# VDD.t3 sg13_lv_pmos ad=0.38p pd=2.38u as=0.38p ps=2.38u w=2u l=0.13u
X53 a_3317_2122# a_2907_2122# VDD.t13 VDD.t3 sg13_lv_pmos ad=0.68p pd=4.68u as=0.68p ps=4.68u w=2u l=0.13u
X54 a_3521_3236# VOUT.t9 VSS rppd l=0.5u w=0.5u
X55 VSS.t150 VSS.t151 VSS rppd l=0.5u w=0.5u
X56 VSS.t168 VSS.t169 VSS rppd l=0.5u w=0.5u
X57 a_917_3663.t1 a_917_3663.t0 VDD.t32 VDD.t0 sg13_lv_pmos ad=0.68p pd=4.68u as=0.68p ps=4.68u w=2u l=0.13u
X58 VSS.t134 Vctr.t2 a_1369_2844# VSS.t132 sg13_lv_nmos ad=0.34p pd=2.68u as=0.19p ps=1.38u w=1u l=0.13u
X59 VSS.t73 VSS.t74 VSS rppd l=0.5u w=0.5u
X60 a_3009_2844# a_2584_2122# a_2907_2122# VSS.t102 sg13_lv_nmos ad=0.19p pd=1.38u as=0.19p ps=1.38u w=1u l=0.13u
X61 a_1267_5464# RST.t1 VSS.t127 VSS.t126 sg13_lv_nmos ad=0.19p pd=1.38u as=0.34p ps=2.68u w=1u l=0.13u
X62 a_2805_5072# a_1839_4350# VSS.t52 VSS.t51 sg13_lv_nmos ad=0.19p pd=1.38u as=0.34p ps=2.68u w=1u l=0.13u
X63 VSS.t61 Vref.t1 a_1941_5072# VSS.t59 sg13_lv_nmos ad=0.34p pd=2.68u as=0.19p ps=1.38u w=1u l=0.13u
X64 a_1941_3758# a_1839_4350# a_1839_3236# VDD.t0 sg13_lv_pmos ad=0.38p pd=2.38u as=0.38p ps=2.38u w=2u l=0.13u
X65 a_2380_1008# a_1839_1008.t3 VDD.t73 VDD.t3 sg13_lv_pmos ad=0.68p pd=4.68u as=0.68p ps=4.68u w=2u l=0.13u
X66 a_3521_4350# VOUT.t3 VSS rppd l=0.5u w=0.5u
X67 a_2805_3236# a_1839_3236# VSS.t99 VSS.t98 sg13_lv_nmos ad=0.19p pd=1.38u as=0.34p ps=2.68u w=1u l=0.13u
X68 VSS.t30 VSS.t31 VSS rppd l=0.5u w=0.5u
X69 VDD.t7 a_917_3663.t5 a_1369_5986# VDD.t6 sg13_lv_pmos ad=0.68p pd=4.68u as=0.38p ps=2.38u w=2u l=0.13u
X70 VSS.t166 VSS.t167 VSS rppd l=0.5u w=0.5u
X71 VSS.t157 Vref.t2 a_1941_3236# VSS.t156 sg13_lv_nmos ad=0.34p pd=2.68u as=0.19p ps=1.38u w=1u l=0.13u
X72 VSS.t77 VSS.t78 VSS rppd l=0.5u w=0.5u
X73 a_3009_5986# a_1267_5464# a_2907_5464# VDD.t6 sg13_lv_pmos ad=0.38p pd=2.38u as=0.38p ps=2.38u w=2u l=0.13u
X74 VSS.t106 a_3317_5464# a_3521_5464# VSS.t107 sg13_lv_nmos ad=0.19p pd=1.38u as=0.19p ps=1.38u w=1u l=0.13u
X75 a_3521_4350# a_3317_4350# VSS.t143 VSS.t108 sg13_lv_nmos ad=0.19p pd=1.38u as=0.34p ps=2.68u w=1u l=0.13u
X76 a_2805_4350# a_1839_4350# VDD.t15 VDD.t0 sg13_lv_pmos ad=0.38p pd=2.38u as=0.68p ps=4.68u w=2u l=0.13u
X77 VSS.t24 VSS.t25 VSS rppd l=0.5u w=0.5u
X78 VSS.t136 Vctr.t3 a_1369_1008# VSS.t135 sg13_lv_nmos ad=0.34p pd=2.68u as=0.19p ps=1.38u w=1u l=0.13u
X79 VDD.t10 a_917_2086.t3 a_1941_4350# VDD.t0 sg13_lv_pmos ad=0.68p pd=4.68u as=0.38p ps=2.38u w=2u l=0.13u
X80 a_3009_1008# a_2584_1008# a_2907_1008# VSS.t17 sg13_lv_nmos ad=0.19p pd=1.38u as=0.19p ps=1.38u w=1u l=0.13u
X81 VSS.t91 VSS.t92 VSS rppd l=0.5u w=0.5u
X82 VSS.t15 VSS.t16 VSS rppd l=0.5u w=0.5u
X83 VSS.t68 a_2380_5464# a_3009_5464# VSS.t0 sg13_lv_nmos ad=0.34p pd=2.68u as=0.19p ps=1.38u w=1u l=0.13u
X84 a_1369_3758# a_1267_4350# a_1267_3236# VDD.t0 sg13_lv_pmos ad=0.38p pd=2.38u as=0.38p ps=2.38u w=2u l=0.13u
X85 VSS.t146 VSS.t147 VSS rppd l=0.5u w=0.5u
X86 a_2380_2122# a_1839_2122# VSS.t111 VSS.t100 sg13_lv_nmos ad=0.34p pd=2.68u as=0.34p ps=2.68u w=1u l=0.13u
X87 a_2584_5464# a_1267_5464# VSS.t204 VSS.t178 sg13_lv_nmos ad=0.34p pd=2.68u as=0.34p ps=2.68u w=1u l=0.13u
X88 a_2907_3236# a_2584_3236# a_2805_3758# VDD.t0 sg13_lv_pmos ad=0.38p pd=2.38u as=0.38p ps=2.38u w=2u l=0.13u
X89 VSS.t85 VSS.t86 VSS rppd l=0.5u w=0.5u
X90 VDD.t33 a_917_3663.t6 a_1369_2122# VDD.t3 sg13_lv_pmos ad=0.68p pd=4.68u as=0.38p ps=2.38u w=2u l=0.13u
X91 a_3521_3236# a_3317_3236# VSS.t97 VSS.t96 sg13_lv_nmos ad=0.19p pd=1.38u as=0.34p ps=2.68u w=1u l=0.13u
X92 a_3009_2122# a_1267_2122# a_2907_2122# VDD.t3 sg13_lv_pmos ad=0.38p pd=2.38u as=0.38p ps=2.38u w=2u l=0.13u
X93 VSS.t194 VSS.t195 VSS rppd l=0.5u w=0.5u
X94 a_3521_4350# a_3317_4350# VDD.t41 VDD.t0 sg13_lv_pmos ad=0.38p pd=2.38u as=0.68p ps=4.68u w=2u l=0.13u
X95 a_3521_3236# a_3317_3236# VDD.t22 VDD.t0 sg13_lv_pmos ad=0.68p pd=4.68u as=0.38p ps=2.38u w=2u l=0.13u
X96 a_2380_5464# a_1839_5464# VDD.t38 VDD.t6 sg13_lv_pmos ad=0.68p pd=4.68u as=0.68p ps=4.68u w=2u l=0.13u
X97 VSS.t190 VSS.t191 VSS rppd l=0.5u w=0.5u
X98 VSS.t200 VSS.t201 VSS rppd l=0.5u w=0.5u
X99 a_3317_3236# a_2907_3236# VDD.t2 VDD.t0 sg13_lv_pmos ad=0.68p pd=4.68u as=0.68p ps=4.68u w=2u l=0.13u
X100 a_1941_5464# a_1839_1008.t2 a_1839_5464# VSS.t26 sg13_lv_nmos ad=0.19p pd=1.38u as=0.19p ps=1.38u w=1u l=0.13u
X101 a_1839_4350# VSS.t186 VSS.t187 VSS.t137 sg13_lv_nmos ad=0.19p pd=1.38u as=0.34p ps=2.68u w=1u l=0.13u
X102 a_2380_1008# a_1839_1008.t3 VSS.t209 VSS.t208 sg13_lv_nmos ad=0.34p pd=2.68u as=0.34p ps=2.68u w=1u l=0.13u
X103 a_2805_1530# a_1839_1008.t4 VDD.t74 VDD.t3 sg13_lv_pmos ad=0.38p pd=2.38u as=0.68p ps=4.68u w=2u l=0.13u
X104 VSS.t144 VSS.t145 VSS rppd l=0.5u w=0.5u
X105 VDD.t11 a_917_2086.t4 a_1941_1530# VDD.t3 sg13_lv_pmos ad=0.68p pd=4.68u as=0.38p ps=2.38u w=2u l=0.13u
X106 VSS.t87 VSS.t88 VSS rppd l=0.5u w=0.5u
X107 VSS.t89 VSS.t90 VSS rppd l=0.5u w=0.5u
X108 VSS.t148 VSS.t149 VSS rppd l=0.5u w=0.5u
X109 a_2380_2122# a_1839_2122# VDD.t31 VDD.t3 sg13_lv_pmos ad=0.68p pd=4.68u as=0.68p ps=4.68u w=2u l=0.13u
X110 a_1839_3236# RST.t2 VSS.t129 VSS.t128 sg13_lv_nmos ad=0.19p pd=1.38u as=0.34p ps=2.68u w=1u l=0.13u
X111 a_3521_1008# VOUT.t2 VSS rppd l=0.5u w=0.5u
X112 VSS.t18 VSS.t19 VSS rppd l=0.5u w=0.5u
X113 VSS.t81 VSS.t82 VSS rppd l=0.5u w=0.5u
X114 a_3521_1008# a_3317_1008# VDD.t45 VDD.t3 sg13_lv_pmos ad=0.38p pd=2.38u as=0.68p ps=4.68u w=2u l=0.13u
X115 a_2805_2844# a_1839_2122# VSS.t110 VSS.t98 sg13_lv_nmos ad=0.19p pd=1.38u as=0.34p ps=2.68u w=1u l=0.13u
X116 a_1369_5464# a_1267_1008.t2 a_1267_5464# VSS.t10 sg13_lv_nmos ad=0.19p pd=1.38u as=0.19p ps=1.38u w=1u l=0.13u
X117 a_1267_4350# VSS.t184 VSS.t185 VSS.t126 sg13_lv_nmos ad=0.19p pd=1.38u as=0.34p ps=2.68u w=1u l=0.13u
X118 a_1839_4350# VDD.t55 VDD.t56 VDD.t0 sg13_lv_pmos ad=0.38p pd=2.38u as=0.68p ps=4.68u w=2u l=0.13u
X119 VSS.t158 Vref.t3 a_1941_2844# VSS.t156 sg13_lv_nmos ad=0.34p pd=2.68u as=0.19p ps=1.38u w=1u l=0.13u
X120 a_2907_5464# a_1267_5464# a_2805_5464# VSS.t177 sg13_lv_nmos ad=0.19p pd=1.38u as=0.19p ps=1.38u w=1u l=0.13u
X121 a_3521_4350# VOUT.t7 VSS rppd l=0.5u w=0.5u
X122 VSS.t20 VSS.t21 VSS rppd l=0.5u w=0.5u
X123 a_1267_3236# RST.t3 VSS.t56 VSS.t55 sg13_lv_nmos ad=0.19p pd=1.38u as=0.34p ps=2.68u w=1u l=0.13u
X124 a_3521_1008# VOUT.t1 VSS rppd l=0.5u w=0.5u
X125 a_2805_5986# a_1839_5464# VDD.t37 VDD.t6 sg13_lv_pmos ad=0.38p pd=2.38u as=0.68p ps=4.68u w=2u l=0.13u
X126 a_3521_5464# a_3317_5464# VSS.t106 VSS.t105 sg13_lv_nmos ad=0.34p pd=2.68u as=0.19p ps=1.38u w=1u l=0.13u
X127 a_3521_2122# a_3317_2122# VSS.t206 VSS.t96 sg13_lv_nmos ad=0.19p pd=1.38u as=0.34p ps=2.68u w=1u l=0.13u
X128 VDD.t12 a_917_2086.t5 a_1941_5986# VDD.t6 sg13_lv_pmos ad=0.68p pd=4.68u as=0.38p ps=2.38u w=2u l=0.13u
X129 VSS.t141 a_3317_4350# a_3521_4350# VSS.t107 sg13_lv_nmos ad=0.19p pd=1.38u as=0.19p ps=1.38u w=1u l=0.13u
X130 a_1267_4350# VDD.t67 VDD.t68 VDD.t0 sg13_lv_pmos ad=0.38p pd=2.38u as=0.68p ps=4.68u w=2u l=0.13u
X131 a_3317_5464# a_2907_5464# VSS.t84 VSS.t83 sg13_lv_nmos ad=0.34p pd=2.68u as=0.34p ps=2.68u w=1u l=0.13u
X132 VDD.t34 a_917_3663.t7 a_1369_3758# VDD.t0 sg13_lv_pmos ad=0.68p pd=4.68u as=0.38p ps=2.38u w=2u l=0.13u
X133 VSS.t164 VSS.t165 VSS rppd l=0.5u w=0.5u
X134 VSS.t11 VSS.t12 VSS rppd l=0.5u w=0.5u
X135 a_2805_1008# a_1839_1008.t4 VSS.t211 VSS.t210 sg13_lv_nmos ad=0.19p pd=1.38u as=0.34p ps=2.68u w=1u l=0.13u
X136 a_3521_2122# VOUT.t0 VSS rppd l=0.5u w=0.5u
X137 VSS.t1 a_2380_4350# a_3009_5072# VSS.t0 sg13_lv_nmos ad=0.34p pd=2.68u as=0.19p ps=1.38u w=1u l=0.13u
X138 VSS.t160 Vref.t4 a_1941_1008# VSS.t159 sg13_lv_nmos ad=0.34p pd=2.68u as=0.19p ps=1.38u w=1u l=0.13u
X139 a_2584_4350# a_1267_4350# VSS.t179 VSS.t178 sg13_lv_nmos ad=0.34p pd=2.68u as=0.34p ps=2.68u w=1u l=0.13u
X140 a_3009_3758# a_1267_3236# a_2907_3236# VDD.t0 sg13_lv_pmos ad=0.38p pd=2.38u as=0.38p ps=2.38u w=2u l=0.13u
X141 a_1839_1008.t1 VDD.t65 VDD.t66 VDD.t3 sg13_lv_pmos ad=0.38p pd=2.38u as=0.68p ps=4.68u w=2u l=0.13u
X142 VSS.t94 a_3317_3236# a_3521_3236# VSS.t95 sg13_lv_nmos ad=0.19p pd=1.38u as=0.19p ps=1.38u w=1u l=0.13u
X143 a_2805_2122# a_1839_2122# VDD.t30 VDD.t3 sg13_lv_pmos ad=0.38p pd=2.38u as=0.68p ps=4.68u w=2u l=0.13u
X144 a_3521_5464# a_3317_5464# VDD.t28 VDD.t6 sg13_lv_pmos ad=0.38p pd=2.38u as=0.68p ps=4.68u w=2u l=0.13u
X145 VDD.t42 a_917_2086.t6 a_1941_2122# VDD.t3 sg13_lv_pmos ad=0.68p pd=4.68u as=0.38p ps=2.38u w=2u l=0.13u
X146 VSS.t62 a_2380_3236# a_3009_3236# VSS.t13 sg13_lv_nmos ad=0.34p pd=2.68u as=0.19p ps=1.38u w=1u l=0.13u
X147 VDD.t39 a_3317_4350# a_3521_4350# VDD.t0 sg13_lv_pmos ad=0.38p pd=2.38u as=0.38p ps=2.38u w=2u l=0.13u
X148 a_2584_3236# a_1267_3236# VSS.t48 VSS.t47 sg13_lv_nmos ad=0.34p pd=2.68u as=0.34p ps=2.68u w=1u l=0.13u
X149 a_3521_1008# a_3317_1008# VSS.t175 VSS.t174 sg13_lv_nmos ad=0.19p pd=1.38u as=0.34p ps=2.68u w=1u l=0.13u
X150 VDD.t1 a_2380_4350# a_3009_4350# VDD.t0 sg13_lv_pmos ad=0.68p pd=4.68u as=0.38p ps=2.38u w=2u l=0.13u
X151 a_917_3663.t2 Vctr.t4 VSS.t70 VSS.t69 sg13_lv_nmos ad=0.34p pd=2.68u as=0.34p ps=2.68u w=1u l=0.13u
X152 a_2584_4350# a_1267_4350# VDD.t47 VDD.t0 sg13_lv_pmos ad=0.68p pd=4.68u as=0.68p ps=4.68u w=2u l=0.13u
X153 VSS.t22 VSS.t23 VSS rppd l=0.5u w=0.5u
X154 a_1839_2122# VSS.t182 VSS.t183 VSS.t128 sg13_lv_nmos ad=0.19p pd=1.38u as=0.34p ps=2.68u w=1u l=0.13u
X155 a_3521_5464# VOUT.t5 VSS rppd l=0.5u w=0.5u
X156 a_1941_5072# a_1839_5464# a_1839_4350# VSS.t26 sg13_lv_nmos ad=0.19p pd=1.38u as=0.19p ps=1.38u w=1u l=0.13u
X157 a_3521_2122# a_3317_2122# VDD.t51 VDD.t3 sg13_lv_pmos ad=0.38p pd=2.38u as=0.68p ps=4.68u w=2u l=0.13u
X158 a_1267_1008.t1 VDD.t63 VDD.t64 VDD.t3 sg13_lv_pmos ad=0.38p pd=2.38u as=0.68p ps=4.68u w=2u l=0.13u
X159 VSS.t38 VSS.t39 VSS rppd l=0.5u w=0.5u
X160 a_2380_3236# a_1839_3236# VDD.t25 VDD.t0 sg13_lv_pmos ad=0.68p pd=4.68u as=0.68p ps=4.68u w=2u l=0.13u
X161 VSS.t170 VSS.t171 VSS rppd l=0.5u w=0.5u
X162 VSS.t139 VSS.t140 VSS rppd l=0.5u w=0.5u
X163 a_1941_3236# a_1839_4350# a_1839_3236# VSS.t50 sg13_lv_nmos ad=0.19p pd=1.38u as=0.19p ps=1.38u w=1u l=0.13u
X164 VSS.t198 VSS.t199 VSS rppd l=0.5u w=0.5u
X165 VSS.t196 VSS.t197 VSS rppd l=0.5u w=0.5u
X166 a_1839_5464# VDD.t61 VDD.t62 VDD.t6 sg13_lv_pmos ad=0.38p pd=2.38u as=0.68p ps=4.68u w=2u l=0.13u
X167 VDD.t44 a_3317_1008# a_3521_1008# VDD.t3 sg13_lv_pmos ad=0.38p pd=2.38u as=0.38p ps=2.38u w=2u l=0.13u
X168 VSS.t72 Vctr.t5 a_1369_5464# VSS.t71 sg13_lv_nmos ad=0.34p pd=2.68u as=0.19p ps=1.38u w=1u l=0.13u
X169 a_1267_2122# VSS.t180 VSS.t181 VSS.t55 sg13_lv_nmos ad=0.19p pd=1.38u as=0.34p ps=2.68u w=1u l=0.13u
X170 a_3009_5464# a_2584_5464# a_2907_5464# VSS.t79 sg13_lv_nmos ad=0.19p pd=1.38u as=0.19p ps=1.38u w=1u l=0.13u
X171 a_1369_5072# a_1267_5464# a_1267_4350# VSS.t10 sg13_lv_nmos ad=0.19p pd=1.38u as=0.19p ps=1.38u w=1u l=0.13u
X172 a_1941_4350# a_1839_5464# a_1839_4350# VDD.t0 sg13_lv_pmos ad=0.38p pd=2.38u as=0.38p ps=2.38u w=2u l=0.13u
X173 VSS.t152 VSS.t153 VSS rppd l=0.5u w=0.5u
X174 a_2907_4350# a_1267_4350# a_2805_5072# VSS.t177 sg13_lv_nmos ad=0.19p pd=1.38u as=0.19p ps=1.38u w=1u l=0.13u
X175 a_1839_1008.t0 RST.t4 VSS.t58 VSS.t57 sg13_lv_nmos ad=0.19p pd=1.38u as=0.34p ps=2.68u w=1u l=0.13u
X176 VDD.t26 a_2380_1008# a_3009_1530# VDD.t3 sg13_lv_pmos ad=0.68p pd=4.68u as=0.38p ps=2.38u w=2u l=0.13u
X177 a_2584_1008# a_1267_1008.t5 VDD.t18 VDD.t3 sg13_lv_pmos ad=0.68p pd=4.68u as=0.68p ps=4.68u w=2u l=0.13u
X178 a_1369_3236# a_1267_4350# a_1267_3236# VSS.t49 sg13_lv_nmos ad=0.19p pd=1.38u as=0.19p ps=1.38u w=1u l=0.13u
X179 a_1839_2122# VDD.t59 VDD.t60 VDD.t3 sg13_lv_pmos ad=0.38p pd=2.38u as=0.68p ps=4.68u w=2u l=0.13u
X180 a_2907_3236# a_1267_3236# a_2805_3236# VSS.t46 sg13_lv_nmos ad=0.19p pd=1.38u as=0.19p ps=1.38u w=1u l=0.13u
X181 VSS.t205 a_3317_2122# a_3521_2122# VSS.t95 sg13_lv_nmos ad=0.19p pd=1.38u as=0.19p ps=1.38u w=1u l=0.13u
X182 a_1267_5464# VDD.t57 VDD.t58 VDD.t6 sg13_lv_pmos ad=0.38p pd=2.38u as=0.68p ps=4.68u w=2u l=0.13u
X183 a_3521_4350# a_3317_4350# VSS.t141 VSS.t105 sg13_lv_nmos ad=0.34p pd=2.68u as=0.19p ps=1.38u w=1u l=0.13u
X184 a_3521_2122# VOUT.t8 VSS rppd l=0.5u w=0.5u
X185 a_3317_4350# a_2907_4350# VSS.t121 VSS.t83 sg13_lv_nmos ad=0.34p pd=2.68u as=0.34p ps=2.68u w=1u l=0.13u
X186 a_1369_4350# a_1267_5464# a_1267_4350# VDD.t0 sg13_lv_pmos ad=0.38p pd=2.38u as=0.38p ps=2.38u w=2u l=0.13u
X187 VSS.t192 VSS.t193 VSS rppd l=0.5u w=0.5u
X188 VSS.t14 a_2380_2122# a_3009_2844# VSS.t13 sg13_lv_nmos ad=0.34p pd=2.68u as=0.19p ps=1.38u w=1u l=0.13u
X189 a_2907_4350# a_2584_4350# a_2805_4350# VDD.t0 sg13_lv_pmos ad=0.38p pd=2.38u as=0.38p ps=2.38u w=2u l=0.13u
X190 a_1267_1008.t0 RST.t5 VSS.t33 VSS.t32 sg13_lv_nmos ad=0.19p pd=1.38u as=0.34p ps=2.68u w=1u l=0.13u
X191 a_2584_2122# a_1267_2122# VSS.t202 VSS.t47 sg13_lv_nmos ad=0.34p pd=2.68u as=0.34p ps=2.68u w=1u l=0.13u
X192 VSS.t154 VSS.t155 VSS rppd l=0.5u w=0.5u
X193 VSS.t34 VSS.t35 VSS rppd l=0.5u w=0.5u
X194 a_2805_3758# a_1839_3236# VDD.t24 VDD.t0 sg13_lv_pmos ad=0.38p pd=2.38u as=0.68p ps=4.68u w=2u l=0.13u
X195 a_3521_3236# a_3317_3236# VSS.t94 VSS.t93 sg13_lv_nmos ad=0.34p pd=2.68u as=0.19p ps=1.38u w=1u l=0.13u
X196 a_2380_5464# a_1839_5464# VSS.t130 VSS.t53 sg13_lv_nmos ad=0.34p pd=2.68u as=0.34p ps=2.68u w=1u l=0.13u
X197 VDD.t43 a_917_2086.t7 a_1941_3758# VDD.t0 sg13_lv_pmos ad=0.68p pd=4.68u as=0.38p ps=2.38u w=2u l=0.13u
X198 a_1941_1530# a_1839_2122# a_1839_1008.t1 VDD.t3 sg13_lv_pmos ad=0.38p pd=2.38u as=0.38p ps=2.38u w=2u l=0.13u
X199 VDD.t27 a_3317_5464# a_3521_5464# VDD.t6 sg13_lv_pmos ad=0.38p pd=2.38u as=0.38p ps=2.38u w=2u l=0.13u
X200 VSS.t36 VSS.t37 VSS rppd l=0.5u w=0.5u
X201 a_3317_3236# a_2907_3236# VSS.t3 VSS.t2 sg13_lv_nmos ad=0.34p pd=2.68u as=0.34p ps=2.68u w=1u l=0.13u
X202 a_1267_2122# VDD.t53 VDD.t54 VDD.t3 sg13_lv_pmos ad=0.38p pd=2.38u as=0.68p ps=4.68u w=2u l=0.13u
X203 a_917_2086.t0 Vref.t5 VSS.t161 VSS.t69 sg13_lv_nmos ad=0.34p pd=2.68u as=0.34p ps=2.68u w=1u l=0.13u
X204 VSS.t115 VSS.t116 VSS rppd l=0.5u w=0.5u
X205 VSS.t27 VSS.t28 VSS rppd l=0.5u w=0.5u
X206 a_3521_4350# a_3317_4350# VDD.t39 VDD.t0 sg13_lv_pmos ad=0.68p pd=4.68u as=0.38p ps=2.38u w=2u l=0.13u
X207 VSS.t117 VSS.t118 VSS rppd l=0.5u w=0.5u
X208 VSS.t173 a_3317_1008# a_3521_1008# VSS.t172 sg13_lv_nmos ad=0.19p pd=1.38u as=0.19p ps=1.38u w=1u l=0.13u
X209 a_2584_5464# a_1267_5464# VDD.t49 VDD.t6 sg13_lv_pmos ad=0.68p pd=4.68u as=0.68p ps=4.68u w=2u l=0.13u
X210 VDD.t19 a_2380_5464# a_3009_5986# VDD.t6 sg13_lv_pmos ad=0.68p pd=4.68u as=0.38p ps=2.38u w=2u l=0.13u
X211 a_3521_5464# VOUT.t4 VSS rppd l=0.5u w=0.5u
X212 a_3317_4350# a_2907_4350# VDD.t35 VDD.t0 sg13_lv_pmos ad=0.68p pd=4.68u as=0.68p ps=4.68u w=2u l=0.13u
X213 a_3521_3236# a_3317_3236# VDD.t21 VDD.t0 sg13_lv_pmos ad=0.38p pd=2.38u as=0.68p ps=4.68u w=2u l=0.13u
X214 VSS.t42 VSS.t43 VSS rppd l=0.5u w=0.5u
X215 VSS.t40 VSS.t41 VSS rppd l=0.5u w=0.5u
X216 VSS.t104 a_2380_1008# a_3009_1008# VSS.t103 sg13_lv_nmos ad=0.34p pd=2.68u as=0.19p ps=1.38u w=1u l=0.13u
X217 a_1941_2844# a_1839_3236# a_1839_2122# VSS.t50 sg13_lv_nmos ad=0.19p pd=1.38u as=0.19p ps=1.38u w=1u l=0.13u
X218 a_2584_1008# a_1267_1008.t5 VSS.t67 VSS.t66 sg13_lv_nmos ad=0.34p pd=2.68u as=0.34p ps=2.68u w=1u l=0.13u
X219 a_1369_1530# a_1267_2122# a_1267_1008.t1 VDD.t3 sg13_lv_pmos ad=0.38p pd=2.38u as=0.38p ps=2.38u w=2u l=0.13u
X220 VDD.t50 a_3317_2122# a_3521_2122# VDD.t3 sg13_lv_pmos ad=0.38p pd=2.38u as=0.38p ps=2.38u w=2u l=0.13u
X221 a_2907_1008# a_2584_1008# a_2805_1530# VDD.t3 sg13_lv_pmos ad=0.38p pd=2.38u as=0.38p ps=2.38u w=2u l=0.13u
X222 VSS.t124 VSS.t125 VSS rppd l=0.5u w=0.5u
X223 VDD.t8 a_2380_2122# a_3009_2122# VDD.t3 sg13_lv_pmos ad=0.68p pd=4.68u as=0.38p ps=2.38u w=2u l=0.13u
R0 VSS.n201 VSS.n200 21457.7
R1 VSS.n200 VSS.n111 20680.6
R2 VSS.n218 VSS.n25 6169.91
R3 VSS.n218 VSS.n217 4623.55
R4 VSS.n200 VSS.n199 411.603
R5 VSS.t57 VSS.n204 351.786
R6 VSS.t208 VSS.n207 336.762
R7 VSS.t66 VSS.n208 336.726
R8 VSS.t159 VSS.n206 335.56
R9 VSS.n203 VSS.t203 315.526
R10 VSS.n212 VSS.t17 275.459
R11 VSS.n210 VSS.t210 275.459
R12 VSS.n216 VSS.t172 265.442
R13 VSS.t174 VSS.n214 261.601
R14 VSS.t6 VSS.n213 261.601
R15 VSS.t176 VSS.n216 245.41
R16 VSS.t103 VSS.n212 235.393
R17 VSS.t65 VSS.n210 235.393
R18 VSS.n60 VSS.t137 200.773
R19 VSS.t128 VSS.n126 200.773
R20 VSS.t135 VSS.n203 195.327
R21 VSS.t32 VSS.n201 195.327
R22 VSS.n67 VSS.t53 192.486
R23 VSS.t100 VSS.n122 192.486
R24 VSS.t178 VSS.n49 192.386
R25 VSS.n145 VSS.t47 192.386
R26 VSS.t59 VSS.n51 185.083
R27 VSS.n141 VSS.t156 185.083
R28 VSS.t112 VSS.n205 180.733
R29 VSS.n206 VSS.t112 175.292
R30 VSS.t10 VSS.n53 174.034
R31 VSS.n139 VSS.t49 174.034
R32 VSS.n204 VSS.t135 161.471
R33 VSS.n202 VSS.t32 160.7
R34 VSS.t79 VSS.n47 151.935
R35 VSS.n71 VSS.t51 151.935
R36 VSS.n147 VSS.t102 151.935
R37 VSS.t98 VSS.n118 151.935
R38 VSS.n199 VSS.t69 151.935
R39 VSS.t108 VSS.n45 150.95
R40 VSS.n75 VSS.t83 150.95
R41 VSS.n151 VSS.t96 150.95
R42 VSS.t2 VSS.n116 150.95
R43 VSS.n80 VSS.t107 146.41
R44 VSS.t95 VSS.n113 146.41
R45 VSS.n80 VSS.t105 135.359
R46 VSS.n113 VSS.t93 135.359
R47 VSS.t0 VSS.n47 129.834
R48 VSS.n71 VSS.t177 129.834
R49 VSS.n147 VSS.t13 129.834
R50 VSS.t46 VSS.n118 129.834
R51 VSS.t55 VSS.n132 123.424
R52 VSS.n213 VSS.t103 121.37
R53 VSS.n211 VSS.t65 120.633
R54 VSS.n217 VSS.t176 111.395
R55 VSS.n214 VSS.t6 111.353
R56 VSS.n215 VSS.t174 110.617
R57 VSS.t71 VSS.n53 107.736
R58 VSS.n111 VSS.t126 107.736
R59 VSS.n139 VSS.t132 107.736
R60 VSS.n52 VSS.t26 105.555
R61 VSS.t50 VSS.n140 105.555
R62 VSS.t26 VSS.n51 96.6856
R63 VSS.n141 VSS.t50 96.6856
R64 VSS.n60 VSS.t71 95.8024
R65 VSS.t132 VSS.n126 95.8024
R66 VSS.n54 VSS.t126 94.5061
R67 VSS.n138 VSS.t55 94.5061
R68 VSS.t172 VSS.n215 90.5831
R69 VSS.t210 VSS.n209 81.3358
R70 VSS.t17 VSS.n211 80.5664
R71 VSS.n75 VSS.t0 73.6022
R72 VSS.t13 VSS.n116 73.6022
R73 VSS.t177 VSS.n48 72.4066
R74 VSS.n146 VSS.t46 72.4066
R75 VSS.t105 VSS.n25 68.177
R76 VSS.t93 VSS.n33 68.1562
R77 VSS.t83 VSS.n45 68.0773
R78 VSS.n151 VSS.t2 68.0773
R79 VSS.n79 VSS.t108 66.8818
R80 VSS.t96 VSS.n114 66.8818
R81 VSS.t107 VSS.n79 55.832
R82 VSS.n114 VSS.t95 55.832
R83 VSS.n132 VSS.t69 51.6035
R84 VSS.t51 VSS.n68 51.5954
R85 VSS.n121 VSS.t98 51.5954
R86 VSS.n48 VSS.t79 50.3072
R87 VSS.t102 VSS.n146 50.3072
R88 VSS.t203 VSS.n202 40.4996
R89 VSS.n209 VSS.t66 36.2606
R90 VSS.n208 VSS.t208 36.2271
R91 VSS.n54 VSS.t10 28.2077
R92 VSS.t49 VSS.n138 28.2077
R93 VSS.n68 VSS.t178 26.7335
R94 VSS.t47 VSS.n121 26.7335
R95 VSS.t53 VSS.n49 26.6409
R96 VSS.n145 VSS.t100 26.6409
R97 VSS.n221 VSS.n16 23.2647
R98 VSS.n222 VSS.n221 23.2471
R99 VSS.n207 VSS.t159 21.2381
R100 VSS.n205 VSS.t57 20.4662
R101 VSS.n67 VSS.t59 18.4543
R102 VSS.t156 VSS.n122 18.4543
R103 VSS.n221 VSS.n220 18.3543
R104 VSS.t137 VSS.n52 17.158
R105 VSS.n140 VSS.t128 17.158
R106 VSS.n220 VSS.n219 17.001
R107 VSS.n111 VSS.n110 17.0005
R108 VSS.n110 VSS.n53 17.0005
R109 VSS.n110 VSS.n51 17.0005
R110 VSS.n110 VSS.n71 17.0005
R111 VSS.n110 VSS.n47 17.0005
R112 VSS.n110 VSS.n46 17.0005
R113 VSS.n110 VSS.n80 17.0005
R114 VSS.n110 VSS.n16 17.0005
R115 VSS.n201 VSS.n0 17.0005
R116 VSS.n203 VSS.n0 17.0005
R117 VSS.n206 VSS.n0 17.0005
R118 VSS.n210 VSS.n0 17.0005
R119 VSS.n212 VSS.n0 17.0005
R120 VSS.n236 VSS.n0 17.0005
R121 VSS.n216 VSS.n0 17.0005
R122 VSS.n222 VSS.n0 17.0005
R123 VSS.n198 VSS.n133 17.0005
R124 VSS.n199 VSS.n198 17.0005
R125 VSS.n198 VSS.n139 17.0005
R126 VSS.n198 VSS.n141 17.0005
R127 VSS.n198 VSS.n118 17.0005
R128 VSS.n198 VSS.n147 17.0005
R129 VSS.n198 VSS.n150 17.0005
R130 VSS.n198 VSS.n113 17.0005
R131 VSS.n198 VSS.n197 17.0005
R132 VSS.n188 VSS.n187 17.0005
R133 VSS.n187 VSS.n186 17.0005
R134 VSS.n182 VSS.n181 17.0005
R135 VSS.n181 VSS.n180 17.0005
R136 VSS.n61 VSS.t186 15.5174
R137 VSS.n55 VSS.t184 15.5174
R138 VSS.n127 VSS.t182 15.5174
R139 VSS.n135 VSS.t180 15.5174
R140 VSS.n81 VSS.t28 15.3892
R141 VSS.n84 VSS.t37 15.3892
R142 VSS.n1 VSS.t171 15.3892
R143 VSS.n190 VSS.t191 15.3892
R144 VSS.n193 VSS.t90 15.3892
R145 VSS.n37 VSS.t24 15.3864
R146 VSS.n34 VSS.t15 15.3864
R147 VSS.n13 VSS.t119 15.3864
R148 VSS.n20 VSS.t42 15.3864
R149 VSS.n17 VSS.t117 15.3864
R150 VSS.n103 VSS.t148 15.2062
R151 VSS.n106 VSS.t113 15.2062
R152 VSS.n98 VSS.t18 15.2062
R153 VSS.n101 VSS.t34 15.2062
R154 VSS.n93 VSS.t149 15.2062
R155 VSS.n96 VSS.t114 15.2062
R156 VSS.n89 VSS.t19 15.2062
R157 VSS.n92 VSS.t35 15.2062
R158 VSS.n8 VSS.t77 15.2062
R159 VSS.n11 VSS.t198 15.2062
R160 VSS.n4 VSS.t78 15.2062
R161 VSS.n7 VSS.t199 15.2062
R162 VSS.n173 VSS.t63 15.2062
R163 VSS.n176 VSS.t91 15.2062
R164 VSS.n168 VSS.t75 15.2062
R165 VSS.n171 VSS.t144 15.2062
R166 VSS.n160 VSS.t64 15.2062
R167 VSS.n163 VSS.t92 15.2062
R168 VSS.n156 VSS.t76 15.2062
R169 VSS.n159 VSS.t145 15.2062
R170 VSS.n37 VSS.t194 15.0005
R171 VSS.n38 VSS.t4 15.0005
R172 VSS.n39 VSS.t188 15.0005
R173 VSS.n34 VSS.t20 15.0005
R174 VSS.n35 VSS.t152 15.0005
R175 VSS.n36 VSS.t139 15.0005
R176 VSS.n103 VSS.t25 15.0005
R177 VSS.n104 VSS.t195 15.0005
R178 VSS.n105 VSS.t5 15.0005
R179 VSS.n106 VSS.t189 15.0005
R180 VSS.n98 VSS.t16 15.0005
R181 VSS.n99 VSS.t21 15.0005
R182 VSS.n100 VSS.t153 15.0005
R183 VSS.n101 VSS.t140 15.0005
R184 VSS.n93 VSS.t36 15.0005
R185 VSS.n94 VSS.t40 15.0005
R186 VSS.n95 VSS.t38 15.0005
R187 VSS.n96 VSS.t81 15.0005
R188 VSS.n89 VSS.t27 15.0005
R189 VSS.n91 VSS.t166 15.0005
R190 VSS.n90 VSS.t44 15.0005
R191 VSS.n92 VSS.t73 15.0005
R192 VSS.n83 VSS.t74 15.0005
R193 VSS.n82 VSS.t167 15.0005
R194 VSS.n81 VSS.t45 15.0005
R195 VSS.n84 VSS.t41 15.0005
R196 VSS.n85 VSS.t39 15.0005
R197 VSS.n86 VSS.t82 15.0005
R198 VSS.n13 VSS.t200 15.0005
R199 VSS.n14 VSS.t146 15.0005
R200 VSS.n15 VSS.t11 15.0005
R201 VSS.n8 VSS.t120 15.0005
R202 VSS.n9 VSS.t201 15.0005
R203 VSS.n10 VSS.t147 15.0005
R204 VSS.n11 VSS.t12 15.0005
R205 VSS.n4 VSS.t170 15.0005
R206 VSS.n6 VSS.t115 15.0005
R207 VSS.n5 VSS.t124 15.0005
R208 VSS.n7 VSS.t162 15.0005
R209 VSS.n3 VSS.t163 15.0005
R210 VSS.n2 VSS.t116 15.0005
R211 VSS.n1 VSS.t125 15.0005
R212 VSS.n20 VSS.t22 15.0005
R213 VSS.n21 VSS.t87 15.0005
R214 VSS.n22 VSS.t150 15.0005
R215 VSS.n17 VSS.t192 15.0005
R216 VSS.n18 VSS.t8 15.0005
R217 VSS.n19 VSS.t30 15.0005
R218 VSS.n173 VSS.t43 15.0005
R219 VSS.n174 VSS.t23 15.0005
R220 VSS.n175 VSS.t88 15.0005
R221 VSS.n176 VSS.t151 15.0005
R222 VSS.n168 VSS.t118 15.0005
R223 VSS.n169 VSS.t193 15.0005
R224 VSS.n170 VSS.t9 15.0005
R225 VSS.n171 VSS.t31 15.0005
R226 VSS.n160 VSS.t89 15.0005
R227 VSS.n161 VSS.t168 15.0005
R228 VSS.n162 VSS.t122 15.0005
R229 VSS.n163 VSS.t196 15.0005
R230 VSS.n156 VSS.t190 15.0005
R231 VSS.n158 VSS.t164 15.0005
R232 VSS.n157 VSS.t85 15.0005
R233 VSS.n159 VSS.t154 15.0005
R234 VSS.n192 VSS.t155 15.0005
R235 VSS.n191 VSS.t165 15.0005
R236 VSS.n190 VSS.t86 15.0005
R237 VSS.n193 VSS.t169 15.0005
R238 VSS.n194 VSS.t123 15.0005
R239 VSS.n195 VSS.t197 15.0005
R240 VSS.n218 VSS.n33 13.3522
R241 VSS.n218 VSS.n32 8.501
R242 VSS.n218 VSS.n31 8.501
R243 VSS.n218 VSS.n30 8.501
R244 VSS.n218 VSS.n29 8.501
R245 VSS.n218 VSS.n28 8.501
R246 VSS.n218 VSS.n27 8.501
R247 VSS.n218 VSS.n26 8.501
R248 VSS.n219 VSS.n218 8.501
R249 VSS.n189 VSS.n155 8.4798
R250 VSS.n185 VSS.n165 8.4798
R251 VSS.n184 VSS.n166 8.4798
R252 VSS.n183 VSS.n167 8.4798
R253 VSS.n179 VSS.n24 8.4798
R254 VSS.n43 VSS.t141 6.08241
R255 VSS.n77 VSS.t143 6.08241
R256 VSS.n76 VSS.t121 6.08241
R257 VSS.n73 VSS.t1 6.08241
R258 VSS.n72 VSS.t52 6.08241
R259 VSS.n69 VSS.t179 6.08241
R260 VSS.n65 VSS.t54 6.08241
R261 VSS.n64 VSS.t61 6.08241
R262 VSS.n58 VSS.t80 6.08241
R263 VSS.n153 VSS.t205 6.08241
R264 VSS.n152 VSS.t206 6.08241
R265 VSS.n148 VSS.t29 6.08241
R266 VSS.n149 VSS.t14 6.08241
R267 VSS.n119 VSS.t110 6.08241
R268 VSS.n143 VSS.t202 6.08241
R269 VSS.n142 VSS.t111 6.08241
R270 VSS.n124 VSS.t158 6.08241
R271 VSS.n130 VSS.t134 6.08241
R272 VSS.n134 VSS.t161 6.08241
R273 VSS.n43 VSS.t106 6.08198
R274 VSS.n77 VSS.t109 6.08198
R275 VSS.n76 VSS.t84 6.08198
R276 VSS.n73 VSS.t68 6.08198
R277 VSS.n72 VSS.t131 6.08198
R278 VSS.n69 VSS.t204 6.08198
R279 VSS.n65 VSS.t130 6.08198
R280 VSS.n64 VSS.t60 6.08198
R281 VSS.n62 VSS.t138 6.08198
R282 VSS.n58 VSS.t72 6.08198
R283 VSS.n56 VSS.t127 6.08198
R284 VSS.n231 VSS.t173 6.08198
R285 VSS.n233 VSS.t175 6.08198
R286 VSS.n235 VSS.t7 6.08198
R287 VSS.n237 VSS.t104 6.08198
R288 VSS.n239 VSS.t211 6.08198
R289 VSS.n241 VSS.t67 6.08198
R290 VSS.n243 VSS.t209 6.08198
R291 VSS.n245 VSS.t160 6.08198
R292 VSS.n247 VSS.t58 6.08198
R293 VSS.n249 VSS.t136 6.08198
R294 VSS.n251 VSS.t33 6.08198
R295 VSS.n153 VSS.t94 6.08198
R296 VSS.n152 VSS.t97 6.08198
R297 VSS.n148 VSS.t3 6.08198
R298 VSS.n149 VSS.t62 6.08198
R299 VSS.n119 VSS.t99 6.08198
R300 VSS.n143 VSS.t48 6.08198
R301 VSS.n142 VSS.t101 6.08198
R302 VSS.n124 VSS.t157 6.08198
R303 VSS.n128 VSS.t129 6.08198
R304 VSS.n130 VSS.t133 6.08198
R305 VSS.n136 VSS.t56 6.08198
R306 VSS.n134 VSS.t70 6.08198
R307 VSS.n110 VSS.n50 5.6302
R308 VSS.n110 VSS.n70 5.6302
R309 VSS.n110 VSS.n78 5.6302
R310 VSS.n110 VSS.n44 5.6302
R311 VSS.n110 VSS.n41 5.6302
R312 VSS.n242 VSS.n0 5.6302
R313 VSS.n240 VSS.n0 5.6302
R314 VSS.n234 VSS.n0 5.6302
R315 VSS.n232 VSS.n0 5.6302
R316 VSS.n224 VSS.n0 5.6302
R317 VSS.n198 VSS.n144 5.6302
R318 VSS.n198 VSS.n120 5.6302
R319 VSS.n198 VSS.n115 5.6302
R320 VSS.n198 VSS.n154 5.6302
R321 VSS.n61 VSS.t187 5.56245
R322 VSS.n55 VSS.t185 5.56245
R323 VSS.n127 VSS.t183 5.56245
R324 VSS.n135 VSS.t181 5.56245
R325 VSS.n110 VSS.n59 4.19857
R326 VSS.n110 VSS.n63 4.19857
R327 VSS.n110 VSS.n66 4.19857
R328 VSS.n110 VSS.n88 4.19857
R329 VSS.n248 VSS.n0 4.19857
R330 VSS.n246 VSS.n0 4.19857
R331 VSS.n244 VSS.n0 4.19857
R332 VSS.n228 VSS.n0 4.19857
R333 VSS.n198 VSS.n137 4.19857
R334 VSS.n198 VSS.n129 4.19857
R335 VSS.n198 VSS.n125 4.19857
R336 VSS.n198 VSS.n123 4.19857
R337 VSS.n110 VSS.n57 3.33426
R338 VSS.n110 VSS.n42 3.33426
R339 VSS.n250 VSS.n0 3.33426
R340 VSS.n230 VSS.n0 3.33426
R341 VSS.n198 VSS.n131 3.33426
R342 VSS.n198 VSS.n112 3.33426
R343 VSS.n110 VSS.n74 2.75376
R344 VSS.n238 VSS.n0 2.75376
R345 VSS.n198 VSS.n117 2.75376
R346 VSS.n110 VSS.n109 2.01901
R347 VSS.n226 VSS.n0 2.01901
R348 VSS.n110 VSS.n54 1.30371
R349 VSS.n110 VSS.n52 1.30371
R350 VSS.n110 VSS.n48 1.30371
R351 VSS.n110 VSS.n79 1.30371
R352 VSS.n198 VSS.n138 1.30371
R353 VSS.n198 VSS.n140 1.30371
R354 VSS.n198 VSS.n146 1.30371
R355 VSS.n198 VSS.n114 1.30371
R356 VSS.n202 VSS.n0 0.772556
R357 VSS.n205 VSS.n0 0.772556
R358 VSS.n211 VSS.n0 0.772556
R359 VSS.n215 VSS.n0 0.772556
R360 VSS.n62 VSS.n61 0.520462
R361 VSS.n56 VSS.n55 0.520462
R362 VSS.n128 VSS.n127 0.520462
R363 VSS.n136 VSS.n135 0.520462
R364 VSS.n95 VSS.n94 0.394667
R365 VSS.n91 VSS.n90 0.394667
R366 VSS.n82 VSS.n81 0.394667
R367 VSS.n85 VSS.n84 0.394667
R368 VSS.n6 VSS.n5 0.394667
R369 VSS.n2 VSS.n1 0.394667
R370 VSS.n162 VSS.n161 0.394667
R371 VSS.n158 VSS.n157 0.394667
R372 VSS.n191 VSS.n190 0.394667
R373 VSS.n194 VSS.n193 0.394667
R374 VSS.n38 VSS.n37 0.391902
R375 VSS.n35 VSS.n34 0.391902
R376 VSS.n105 VSS.n104 0.391902
R377 VSS.n100 VSS.n99 0.391902
R378 VSS.n14 VSS.n13 0.391902
R379 VSS.n10 VSS.n9 0.391902
R380 VSS.n21 VSS.n20 0.391902
R381 VSS.n18 VSS.n17 0.391902
R382 VSS.n175 VSS.n174 0.391902
R383 VSS.n170 VSS.n169 0.391902
R384 VSS.n83 VSS.n82 0.389167
R385 VSS.n86 VSS.n85 0.389167
R386 VSS.n3 VSS.n2 0.389167
R387 VSS.n192 VSS.n191 0.389167
R388 VSS.n195 VSS.n194 0.389167
R389 VSS.n39 VSS.n38 0.386402
R390 VSS.n36 VSS.n35 0.386402
R391 VSS.n15 VSS.n14 0.386402
R392 VSS.n22 VSS.n21 0.386402
R393 VSS.n19 VSS.n18 0.386402
R394 VSS.n109 VSS.n97 0.376632
R395 VSS.n227 VSS.n226 0.376632
R396 VSS.n87 VSS.n83 0.361667
R397 VSS.n87 VSS.n86 0.361667
R398 VSS.n229 VSS.n3 0.361667
R399 VSS.n196 VSS.n192 0.361667
R400 VSS.n196 VSS.n195 0.361667
R401 VSS.n40 VSS.n39 0.360284
R402 VSS.n40 VSS.n36 0.360284
R403 VSS.n223 VSS.n15 0.360284
R404 VSS.n23 VSS.n22 0.360284
R405 VSS.n23 VSS.n19 0.360284
R406 VSS.n109 VSS.n108 0.310149
R407 VSS.n226 VSS.n225 0.310149
R408 VSS.n96 VSS.n95 0.304833
R409 VSS.n94 VSS.n93 0.304833
R410 VSS.n90 VSS.n89 0.304833
R411 VSS.n92 VSS.n91 0.304833
R412 VSS.n5 VSS.n4 0.304833
R413 VSS.n7 VSS.n6 0.304833
R414 VSS.n163 VSS.n162 0.304833
R415 VSS.n161 VSS.n160 0.304833
R416 VSS.n157 VSS.n156 0.304833
R417 VSS.n159 VSS.n158 0.304833
R418 VSS.n104 VSS.n103 0.304646
R419 VSS.n99 VSS.n98 0.304646
R420 VSS.n9 VSS.n8 0.304646
R421 VSS.n174 VSS.n173 0.304646
R422 VSS.n169 VSS.n168 0.304646
R423 VSS.n107 VSS.n105 0.303451
R424 VSS.n102 VSS.n100 0.303451
R425 VSS.n12 VSS.n10 0.303451
R426 VSS.n177 VSS.n175 0.303451
R427 VSS.n172 VSS.n170 0.303451
R428 VSS.n108 VSS.n102 0.277333
R429 VSS.n108 VSS.n107 0.277333
R430 VSS.n97 VSS.n92 0.277333
R431 VSS.n97 VSS.n96 0.277333
R432 VSS.n225 VSS.n12 0.277333
R433 VSS.n227 VSS.n7 0.277333
R434 VSS.n178 VSS.n172 0.277333
R435 VSS.n178 VSS.n177 0.277333
R436 VSS.n164 VSS.n159 0.277333
R437 VSS.n164 VSS.n163 0.277333
R438 VSS.n74 VSS.n72 0.260169
R439 VSS.n239 VSS.n238 0.260169
R440 VSS.n119 VSS.n117 0.260169
R441 VSS.n74 VSS.n73 0.248456
R442 VSS.n238 VSS.n237 0.248456
R443 VSS.n149 VSS.n117 0.248456
R444 VSS.n87 VSS.n42 0.247269
R445 VSS.n230 VSS.n229 0.247269
R446 VSS.n196 VSS.n112 0.247269
R447 VSS.n137 VSS.n134 0.208819
R448 VSS.n137 VSS.n136 0.198056
R449 VSS.n58 VSS.n57 0.197269
R450 VSS.n250 VSS.n249 0.197269
R451 VSS.n131 VSS.n130 0.197269
R452 VSS.n63 VSS.n62 0.193819
R453 VSS.n247 VSS.n246 0.193819
R454 VSS.n128 VSS.n125 0.193819
R455 VSS.n64 VSS.n63 0.190556
R456 VSS.n246 VSS.n245 0.190556
R457 VSS.n125 VSS.n124 0.190556
R458 VSS.n59 VSS.n58 0.186319
R459 VSS.n249 VSS.n248 0.186319
R460 VSS.n130 VSS.n129 0.186319
R461 VSS.n57 VSS.n56 0.185996
R462 VSS.n251 VSS.n250 0.185996
R463 VSS.n136 VSS.n131 0.185996
R464 VSS.n43 VSS.n42 0.173496
R465 VSS.n231 VSS.n230 0.173496
R466 VSS.n153 VSS.n112 0.173496
R467 VSS.n184 VSS.n183 0.171288
R468 VSS.n185 VSS.n184 0.171288
R469 VSS.n44 VSS.n43 0.168406
R470 VSS.n78 VSS.n77 0.168406
R471 VSS.n232 VSS.n231 0.168406
R472 VSS.n234 VSS.n233 0.168406
R473 VSS.n154 VSS.n153 0.168406
R474 VSS.n152 VSS.n115 0.168406
R475 VSS.n70 VSS.n69 0.154994
R476 VSS.n65 VSS.n50 0.154994
R477 VSS.n241 VSS.n240 0.154994
R478 VSS.n243 VSS.n242 0.154994
R479 VSS.n143 VSS.n120 0.154994
R480 VSS.n144 VSS.n142 0.154994
R481 VSS.n108 VSS.n41 0.152494
R482 VSS.n225 VSS.n224 0.152494
R483 VSS.n66 VSS.n64 0.151319
R484 VSS.n245 VSS.n244 0.151319
R485 VSS.n124 VSS.n123 0.151319
R486 VSS.n62 VSS.n59 0.148056
R487 VSS.n248 VSS.n247 0.148056
R488 VSS.n129 VSS.n128 0.148056
R489 VSS.n66 VSS.n65 0.144306
R490 VSS.n244 VSS.n243 0.144306
R491 VSS.n142 VSS.n123 0.144306
R492 VSS.n88 VSS.n87 0.136319
R493 VSS.n229 VSS.n228 0.136319
R494 VSS.n97 VSS.n88 0.130556
R495 VSS.n228 VSS.n227 0.130556
R496 VSS.n180 VSS.n179 0.128394
R497 VSS.n183 VSS.n182 0.128394
R498 VSS.n186 VSS.n185 0.128394
R499 VSS.n189 VSS.n188 0.128394
R500 VSS.n197 VSS.n189 0.128394
R501 VSS.n72 VSS.n70 0.123406
R502 VSS.n240 VSS.n239 0.123406
R503 VSS.n120 VSS.n119 0.123406
R504 VSS VSS.n251 0.118
R505 VSS.n56 VSS 0.11675
R506 VSS.n41 VSS.n40 0.114656
R507 VSS.n224 VSS.n223 0.114656
R508 VSS.n69 VSS.n50 0.102156
R509 VSS.n242 VSS.n241 0.102156
R510 VSS.n144 VSS.n143 0.102156
R511 VSS.n110 VSS.n49 0.101454
R512 VSS.n110 VSS.n75 0.101454
R513 VSS.n110 VSS.n45 0.101454
R514 VSS.n198 VSS.n145 0.101454
R515 VSS.n198 VSS.n116 0.101454
R516 VSS.n198 VSS.n151 0.101454
R517 VSS.n77 VSS.n44 0.0887435
R518 VSS.n78 VSS.n76 0.0887435
R519 VSS.n233 VSS.n232 0.0887435
R520 VSS.n235 VSS.n234 0.0887435
R521 VSS.n154 VSS.n152 0.0887435
R522 VSS.n148 VSS.n115 0.0887435
R523 VSS.n76 VSS.n46 0.083
R524 VSS.n236 VSS.n235 0.083
R525 VSS.n186 VSS.n164 0.083
R526 VSS.n150 VSS.n148 0.083
R527 VSS.n179 VSS.n23 0.072144
R528 VSS.n180 VSS.n178 0.06675
R529 VSS.n133 VSS 0.063
R530 VSS.n40 VSS.n16 0.05675
R531 VSS.n223 VSS.n222 0.05675
R532 VSS.n220 VSS.n23 0.05675
R533 VSS.n73 VSS.n46 0.048
R534 VSS.n237 VSS.n236 0.048
R535 VSS.n150 VSS.n149 0.048
R536 VSS.n208 VSS.n0 0.0361125
R537 VSS.n213 VSS.n0 0.0361125
R538 VSS.n214 VSS.n0 0.0361125
R539 VSS.n198 VSS.n33 0.022443
R540 VSS.n182 VSS.n178 0.01925
R541 VSS.n110 VSS.n68 0.00874649
R542 VSS.n198 VSS.n121 0.00874649
R543 VSS.n197 VSS.n196 0.008
R544 VSS.n134 VSS.n133 0.0055
R545 VSS.n188 VSS.n164 0.003
R546 VSS.n110 VSS.n25 0.002615
R547 VSS.n209 VSS.n0 0.00259793
R548 VSS.n107 VSS.n106 0.00169565
R549 VSS.n102 VSS.n101 0.00169565
R550 VSS.n12 VSS.n11 0.00169565
R551 VSS.n177 VSS.n176 0.00169565
R552 VSS.n172 VSS.n171 0.00169565
R553 VSS.n110 VSS.n60 0.00163568
R554 VSS.n110 VSS.n67 0.00163568
R555 VSS.n198 VSS.n132 0.00163568
R556 VSS.n198 VSS.n126 0.00163568
R557 VSS.n198 VSS.n122 0.00163568
R558 VSS.n204 VSS.n0 0.00109541
R559 VSS.n207 VSS.n0 0.00109541
R560 VSS.n217 VSS.n0 0.00100302
R561 VSS.n26 VSS.n24 0.001
R562 VSS.n181 VSS.n27 0.001
R563 VSS.n167 VSS.n28 0.001
R564 VSS.n166 VSS.n29 0.001
R565 VSS.n165 VSS.n30 0.001
R566 VSS.n187 VSS.n31 0.001
R567 VSS.n155 VSS.n32 0.001
R568 VSS.n198 VSS.n32 0.001
R569 VSS.n155 VSS.n31 0.001
R570 VSS.n187 VSS.n30 0.001
R571 VSS.n165 VSS.n29 0.001
R572 VSS.n166 VSS.n28 0.001
R573 VSS.n167 VSS.n27 0.001
R574 VSS.n181 VSS.n26 0.001
R575 VSS.n219 VSS.n24 0.001
R576 VDD.n81 VDD.n52 23.8443
R577 VDD.n82 VDD.n81 23.821
R578 VDD.n81 VDD.n80 18.9298
R579 VDD.n46 VDD.n27 17.0005
R580 VDD.n30 VDD.n27 17.0005
R581 VDD.n84 VDD.n83 17.0005
R582 VDD.n83 VDD.n2 17.0005
R583 VDD.n79 VDD.n55 17.0005
R584 VDD.n11 VDD.t59 15.8663
R585 VDD.n5 VDD.t53 15.8663
R586 VDD.n64 VDD.t55 15.8393
R587 VDD.n57 VDD.t67 15.8393
R588 VDD.n29 VDD.t57 15.8385
R589 VDD.n28 VDD.t61 15.8385
R590 VDD.n12 VDD.t65 15.8385
R591 VDD.n6 VDD.t63 15.8385
R592 VDD.n65 VDD.t71 15.8385
R593 VDD.n58 VDD.t69 15.8385
R594 VDD.n50 VDD.n27 5.6302
R595 VDD.n48 VDD.n27 5.6302
R596 VDD.n42 VDD.n27 5.6302
R597 VDD.n40 VDD.n27 5.6302
R598 VDD.n83 VDD.n3 5.6302
R599 VDD.n83 VDD.n19 5.6302
R600 VDD.n83 VDD.n25 5.6302
R601 VDD.n83 VDD.n1 5.6302
R602 VDD.n79 VDD.n56 5.6302
R603 VDD.n79 VDD.n72 5.6302
R604 VDD.n79 VDD.n78 5.6302
R605 VDD.n79 VDD.n54 5.6302
R606 VDD.n36 VDD.n27 4.19857
R607 VDD.n34 VDD.n27 4.19857
R608 VDD.n32 VDD.n27 4.19857
R609 VDD.n83 VDD.n4 4.19857
R610 VDD.n83 VDD.n10 4.19857
R611 VDD.n83 VDD.n14 4.19857
R612 VDD.n83 VDD.n17 4.19857
R613 VDD.n79 VDD.n63 4.19857
R614 VDD.n79 VDD.n67 4.19857
R615 VDD.n79 VDD.n70 4.19857
R616 VDD.n38 VDD.n27 4.19535
R617 VDD.n51 VDD.t27 3.46158
R618 VDD.n26 VDD.t44 3.46158
R619 VDD.n53 VDD.t22 3.46158
R620 VDD.n26 VDD.t50 3.4611
R621 VDD.n53 VDD.t39 3.4611
R622 VDD.n33 VDD.t7 3.46092
R623 VDD.n37 VDD.t12 3.46092
R624 VDD.n39 VDD.t38 3.46092
R625 VDD.n41 VDD.t49 3.46092
R626 VDD.n43 VDD.t37 3.46092
R627 VDD.n45 VDD.t19 3.46092
R628 VDD.n47 VDD.t20 3.46092
R629 VDD.n49 VDD.t28 3.46092
R630 VDD.n24 VDD.t45 3.46092
R631 VDD.n23 VDD.t4 3.46092
R632 VDD.n21 VDD.t26 3.46092
R633 VDD.n20 VDD.t74 3.46092
R634 VDD.n18 VDD.t18 3.46092
R635 VDD.n16 VDD.t73 3.46092
R636 VDD.n15 VDD.t11 3.46092
R637 VDD.n9 VDD.t5 3.46092
R638 VDD.n77 VDD.t21 3.46092
R639 VDD.n76 VDD.t2 3.46092
R640 VDD.n74 VDD.t17 3.46092
R641 VDD.n73 VDD.t24 3.46092
R642 VDD.n71 VDD.t14 3.46092
R643 VDD.n69 VDD.t25 3.46092
R644 VDD.n68 VDD.t43 3.46092
R645 VDD.n62 VDD.t34 3.46092
R646 VDD.n59 VDD.t32 3.46092
R647 VDD.n24 VDD.t51 3.46001
R648 VDD.n23 VDD.t13 3.46001
R649 VDD.n21 VDD.t8 3.46001
R650 VDD.n20 VDD.t30 3.46001
R651 VDD.n18 VDD.t48 3.46001
R652 VDD.n16 VDD.t31 3.46001
R653 VDD.n15 VDD.t42 3.46001
R654 VDD.n9 VDD.t33 3.46001
R655 VDD.n0 VDD.t9 3.46001
R656 VDD.n77 VDD.t41 3.46001
R657 VDD.n76 VDD.t35 3.46001
R658 VDD.n74 VDD.t1 3.46001
R659 VDD.n73 VDD.t15 3.46001
R660 VDD.n71 VDD.t47 3.46001
R661 VDD.n69 VDD.t16 3.46001
R662 VDD.n68 VDD.t10 3.46001
R663 VDD.n62 VDD.t36 3.46001
R664 VDD.n83 VDD.n8 3.33426
R665 VDD.n79 VDD.n61 3.33426
R666 VDD.n44 VDD.n27 2.75376
R667 VDD.n83 VDD.n22 2.75376
R668 VDD.n79 VDD.n75 2.75376
R669 VDD.n29 VDD.t58 2.61969
R670 VDD.n28 VDD.t62 2.61969
R671 VDD.n11 VDD.t60 2.61969
R672 VDD.n12 VDD.t66 2.61969
R673 VDD.n5 VDD.t54 2.61969
R674 VDD.n6 VDD.t64 2.61969
R675 VDD.n64 VDD.t56 2.61969
R676 VDD.n65 VDD.t72 2.61969
R677 VDD.n57 VDD.t68 2.61969
R678 VDD.n58 VDD.t70 2.61969
R679 VDD.n31 VDD.n29 0.842724
R680 VDD.n35 VDD.n28 0.842724
R681 VDD.n13 VDD.n12 0.842724
R682 VDD.n7 VDD.n6 0.842724
R683 VDD.n66 VDD.n65 0.842724
R684 VDD.n60 VDD.n58 0.842724
R685 VDD.n13 VDD.n11 0.841986
R686 VDD.n7 VDD.n5 0.841986
R687 VDD.n66 VDD.n64 0.841986
R688 VDD.n60 VDD.n57 0.841986
R689 VDD.n82 VDD.n26 0.732983
R690 VDD.n80 VDD.n53 0.732983
R691 VDD.n52 VDD.n51 0.722329
R692 VDD.n52 VDD.n27 0.577649
R693 VDD.n83 VDD.n82 0.577649
R694 VDD.n80 VDD.n79 0.577649
R695 VDD.n60 VDD.n59 0.4055
R696 VDD.n27 VDD.t6 0.298746
R697 VDD.n79 VDD.t0 0.298746
R698 VDD.n83 VDD.t3 0.274694
R699 VDD.n22 VDD.n20 0.260169
R700 VDD.n75 VDD.n73 0.260169
R701 VDD.n44 VDD.n43 0.258456
R702 VDD.n45 VDD.n44 0.250169
R703 VDD.n22 VDD.n21 0.248456
R704 VDD.n75 VDD.n74 0.248456
R705 VDD.n32 VDD.n31 0.210556
R706 VDD.n37 VDD.n36 0.208819
R707 VDD.n4 VDD.n0 0.208819
R708 VDD.n7 VDD.n4 0.198056
R709 VDD.n9 VDD.n8 0.197269
R710 VDD.n62 VDD.n61 0.197269
R711 VDD.n14 VDD.n13 0.193819
R712 VDD.n67 VDD.n66 0.193819
R713 VDD.n15 VDD.n14 0.190556
R714 VDD.n68 VDD.n67 0.190556
R715 VDD.n10 VDD.n9 0.186319
R716 VDD.n63 VDD.n62 0.186319
R717 VDD.n8 VDD.n7 0.185996
R718 VDD.n61 VDD.n60 0.185996
R719 VDD.n36 VDD.n35 0.175556
R720 VDD.n33 VDD.n32 0.173819
R721 VDD.n51 VDD.n50 0.168744
R722 VDD.n49 VDD.n48 0.168744
R723 VDD.n26 VDD.n1 0.168406
R724 VDD.n25 VDD.n24 0.168406
R725 VDD.n54 VDD.n53 0.168406
R726 VDD.n78 VDD.n77 0.168406
R727 VDD.n34 VDD.n33 0.168056
R728 VDD.n35 VDD.n34 0.166319
R729 VDD.n39 VDD.n38 0.158011
R730 VDD.n19 VDD.n18 0.154994
R731 VDD.n16 VDD.n3 0.154994
R732 VDD.n72 VDD.n71 0.154994
R733 VDD.n69 VDD.n56 0.154994
R734 VDD.n42 VDD.n41 0.154656
R735 VDD.n40 VDD.n39 0.154656
R736 VDD.n17 VDD.n15 0.151319
R737 VDD.n70 VDD.n68 0.151319
R738 VDD.n13 VDD.n10 0.148056
R739 VDD.n66 VDD.n63 0.148056
R740 VDD.n17 VDD.n16 0.144306
R741 VDD.n70 VDD.n69 0.144306
R742 VDD.n38 VDD.n37 0.137341
R743 VDD.n43 VDD.n42 0.123744
R744 VDD.n20 VDD.n19 0.123406
R745 VDD.n73 VDD.n72 0.123406
R746 VDD.n59 VDD 0.1155
R747 VDD.n30 VDD 0.10425
R748 VDD.n41 VDD.n40 0.102494
R749 VDD.n18 VDD.n3 0.102156
R750 VDD.n71 VDD.n56 0.102156
R751 VDD.n24 VDD.n1 0.0887435
R752 VDD.n25 VDD.n23 0.0887435
R753 VDD.n77 VDD.n54 0.0887435
R754 VDD.n78 VDD.n76 0.0887435
R755 VDD.n50 VDD.n49 0.0884057
R756 VDD.n48 VDD.n47 0.0884057
R757 VDD.n47 VDD.n46 0.083
R758 VDD.n23 VDD.n2 0.083
R759 VDD.n76 VDD.n55 0.083
R760 VDD.n46 VDD.n45 0.048
R761 VDD.n21 VDD.n2 0.048
R762 VDD.n74 VDD.n55 0.048
R763 VDD VDD.n84 0.038
R764 VDD.n84 VDD.n0 0.0055
R765 VDD.n31 VDD.n30 0.003
R766 VOUT.n2 VOUT.n0 15.7803
R767 VOUT.n7 VOUT.t4 15.2221
R768 VOUT.n3 VOUT.t9 15.2221
R769 VOUT.n1 VOUT.t0 15.2221
R770 VOUT.n0 VOUT.t2 15.2221
R771 VOUT.n5 VOUT.t3 15.2221
R772 VOUT.n7 VOUT.t5 15.1689
R773 VOUT.n3 VOUT.t6 15.1689
R774 VOUT.n1 VOUT.t8 15.1689
R775 VOUT.n0 VOUT.t1 15.1689
R776 VOUT.n5 VOUT.t7 15.1689
R777 VOUT.n4 VOUT.n3 14.5626
R778 VOUT.n2 VOUT.n1 14.5626
R779 VOUT VOUT.n6 10.2579
R780 VOUT.n6 VOUT 9.02372
R781 VOUT VOUT.n7 5.53939
R782 VOUT VOUT.n5 5.53939
R783 VOUT.n4 VOUT.n2 1.2358
R784 VOUT.n6 VOUT.n4 1.2182
R785 a_1839_1008.n2 a_1839_1008.t2 80.5918
R786 a_1839_1008.n0 a_1839_1008.t4 24.9575
R787 a_1839_1008.n0 a_1839_1008.t3 24.2519
R788 a_1839_1008.n1 a_1839_1008.n0 10.4287
R789 a_1839_1008.t0 a_1839_1008.n2 6.4499
R790 a_1839_1008.n1 a_1839_1008.t1 2.90472
R791 a_1839_1008.n2 a_1839_1008.n1 0.864226
R792 a_917_2086.n3 a_917_2086.n2 38.6053
R793 a_917_2086.n2 a_917_2086.t4 35.4418
R794 a_917_2086.n0 a_917_2086.t5 35.4155
R795 a_917_2086.n1 a_917_2086.t7 33.3019
R796 a_917_2086.n2 a_917_2086.t6 33.3019
R797 a_917_2086.n0 a_917_2086.t3 33.2887
R798 a_917_2086.n3 a_917_2086.t1 15.0005
R799 a_917_2086.t0 a_917_2086.n3 6.7341
R800 a_917_2086.n3 a_917_2086.t2 3.46158
R801 a_917_2086.n1 a_917_2086.n0 2.14693
R802 a_917_2086.n2 a_917_2086.n1 2.11633
R803 Vctr.n1 Vctr.t3 36.8093
R804 Vctr.n0 Vctr.t5 35.0905
R805 Vctr.n0 Vctr.t0 33.5021
R806 Vctr.n2 Vctr.t1 33.5021
R807 Vctr.n1 Vctr.t2 33.5021
R808 Vctr.n4 Vctr.n3 28.8641
R809 Vctr.n4 Vctr.t4 24.1891
R810 Vctr.n3 Vctr.n0 3.0981
R811 Vctr.n2 Vctr.n1 1.5889
R812 Vctr.n3 Vctr.n2 0.2161
R813 Vctr Vctr.n4 0.201643
R814 Vref.n3 Vref.t4 36.5878
R815 Vref.n0 Vref.t0 35.0698
R816 Vref.n2 Vref.t3 33.5087
R817 Vref.n1 Vref.t2 33.5087
R818 Vref.n0 Vref.t1 33.5087
R819 Vref.n4 Vref.n3 30.2191
R820 Vref.n4 Vref.t5 24.187
R821 Vref.n1 Vref.n0 3.28639
R822 Vref.n2 Vref.n1 1.56159
R823 Vref Vref.n4 0.203738
R824 Vref.n3 Vref.n2 0.17999
R825 a_1267_1008.n3 a_1267_1008.t2 62.1316
R826 a_1267_1008.n0 a_1267_1008.t4 33.8246
R827 a_1267_1008.n2 a_1267_1008.n1 30.9319
R828 a_1267_1008.n1 a_1267_1008.t5 24.2519
R829 a_1267_1008.n0 a_1267_1008.t3 15.0005
R830 a_1267_1008.n1 a_1267_1008.n0 9.7067
R831 a_1267_1008.t0 a_1267_1008.n3 6.4499
R832 a_1267_1008.n2 a_1267_1008.t1 2.74809
R833 a_1267_1008.n3 a_1267_1008.n2 1.0385
R834 a_917_3663.n1 a_917_3663.t4 35.7362
R835 a_917_3663.n0 a_917_3663.t5 35.7056
R836 a_917_3663.n0 a_917_3663.t3 33.3019
R837 a_917_3663.n1 a_917_3663.t6 33.3019
R838 a_917_3663.n3 a_917_3663.t7 24.0005
R839 a_917_3663.n4 a_917_3663.t0 15.0005
R840 a_917_3663.n4 a_917_3663.n3 10.0675
R841 a_917_3663.n3 a_917_3663.n2 9.3019
R842 a_917_3663.n4 a_917_3663.t2 6.73832
R843 a_917_3663.t1 a_917_3663.n4 3.45748
R844 a_917_3663.n2 a_917_3663.n0 2.44159
R845 a_917_3663.n2 a_917_3663.n1 2.40639
R846 RST.n0 RST.t0 37.8794
R847 RST.n3 RST.t3 33.5395
R848 RST.n2 RST.t5 33.5329
R849 RST.n1 RST.t4 33.0005
R850 RST.n0 RST.t2 33.0005
R851 RST.n4 RST.t1 24.5593
R852 RST.n2 RST.n1 20.6341
R853 RST.n4 RST.n3 13.8928
R854 RST.n1 RST.n0 4.89751
R855 RST.n3 RST.n2 4.87479
R856 RST RST.n4 0.6275
C0 a_2805_2844# a_2907_2122# 0.09917f
C1 a_3009_2844# a_2380_2122# 0.01182f
C2 a_1839_5464# a_1941_5986# 0.20989f
C3 a_1839_5464# a_2584_5464# 0.20228f
C4 a_3317_1008# VDD 0.71597f
C5 a_1839_3236# VDD 0.72034f
C6 a_4437_1530# a_4437_1742# 0.01085f
C7 a_1267_4350# a_1267_5464# 0.16819f
C8 a_3317_3236# a_1267_3236# 0.01086f
C9 VOUT a_3521_5464# 0.11022f
C10 a_4821_5077# a_4821_4865# 0.01085f
C11 a_2805_2844# a_2584_2122# 0.01463f
C12 a_3009_3758# a_2907_3236# 0.21534f
C13 a_4053_2849# a_4053_2637# 0.01085f
C14 a_1839_3236# a_2584_3236# 0.20243f
C15 a_4437_3758# a_4437_3543# 0.01056f
C16 a_3317_4350# a_3521_4350# 0.40843f
C17 a_3521_5464# a_2907_5464# 0.01245f
C18 a_1941_3236# a_1839_4350# 0.01613f
C19 a_1369_3236# a_1267_4350# 0.01603f
C20 a_4821_4650# a_4821_4865# 0.01056f
C21 a_2584_1008# VDD 0.4728f
C22 a_2907_5464# a_3317_5464# 0.14521f
C23 a_3521_2122# a_3521_1008# 0.03719f
C24 a_4053_2422# a_4053_2637# 0.01056f
C25 a_2584_1008# a_2805_1008# 0.01463f
C26 a_4437_3758# a_4437_3970# 0.01085f
C27 a_2907_2122# a_3317_2122# 0.14521f
C28 a_2907_4350# a_2907_3236# 0.02097f
C29 a_4053_4865# a_4053_5077# 0.01085f
C30 a_2805_4350# VDD 0.22722f
C31 a_4437_5771# a_4437_5559# 0.01085f
C32 a_3009_5464# a_2380_5464# 0.01182f
C33 a_2805_5464# a_2907_5464# 0.09917f
C34 a_1267_4350# a_1839_3236# 0.01817f
C35 a_1839_4350# a_1267_3236# 0.03204f
C36 a_4053_6198# VDD 0.0119f
C37 a_4821_4650# a_4821_4438# 0.01085f
C38 a_3521_5464# a_3521_4350# 0.02864f
C39 a_1839_2122# a_1839_3236# 0.2476f
C40 a_2805_1530# VDD 0.22722f
C41 a_4821_4438# VDD 0.01146f
C42 a_1839_5464# a_1839_4350# 0.23596f
C43 a_2380_4350# a_2907_4350# 0.20077f
C44 a_1267_2122# a_1369_2844# 0.09918f
C45 a_1839_2122# a_1941_2844# 0.09918f
C46 a_4437_3970# VDD 0.01146f
C47 a_1941_2122# VDD 0.22773f
C48 a_1369_5072# a_1267_4350# 0.09919f
C49 a_3317_1008# a_3521_1008# 0.40843f
C50 a_4821_2422# a_4821_2210# 0.01085f
C51 a_3009_3758# VDD 0.22744f
C52 a_3521_3236# a_2907_3236# 0.01245f
C53 a_4821_1315# a_4821_1103# 0.01085f
C54 a_2380_1008# VDD 0.52925f
C55 a_1369_5072# a_1267_5464# 0.02342f
C56 a_4053_1530# a_4053_1742# 0.01085f
C57 a_3009_3236# a_2907_3236# 0.09917f
C58 Vref VDD 0.14237f
C59 a_4821_3543# a_4821_3331# 0.01085f
C60 a_4437_5077# a_4437_4865# 0.01085f
C61 a_4053_6198# a_4053_5986# 0.01085f
C62 a_3317_2122# VDD 0.71605f
C63 a_4821_1742# VDD 0.01146f
C64 Vctr VDD 0.16763f
C65 a_2907_4350# VDD 0.18189f
C66 a_4821_1530# a_4821_1315# 0.01056f
C67 a_2907_4350# a_3009_5072# 0.09922f
C68 a_2380_3236# a_2907_3236# 0.19723f
C69 RST VDD 0.32341f
C70 a_2805_5986# a_2907_5464# 0.20304f
C71 a_3317_3236# a_3317_4350# 0.01806f
C72 a_1941_2122# a_1839_2122# 0.20989f
C73 a_4437_4650# a_4437_4865# 0.01056f
C74 a_4437_2422# a_4437_2210# 0.01085f
C75 a_4437_2210# VDD 0.01146f
C76 a_2380_5464# a_2907_5464# 0.20088f
C77 a_1941_2844# a_1839_3236# 0.02364f
C78 a_1369_2844# a_1267_3236# 0.02351f
C79 VOUT VDD 3.90049f
C80 a_2380_2122# a_2907_2122# 0.19723f
C81 a_1369_4350# VDD 0.22773f
C82 a_2805_5464# a_2584_5464# 0.01463f
C83 a_4437_4650# a_4437_4438# 0.01085f
C84 a_3009_5986# VDD 0.22744f
C85 VDD a_2907_5464# 0.18001f
C86 Vref a_1267_4350# 0.03021f
C87 Vref a_1839_2122# 0.20502f
C88 a_4053_4438# VDD 0.01146f
C89 a_2584_4350# a_2380_4350# 0.79681f
C90 a_1267_2122# a_2907_2122# 0.37474f
C91 a_2584_2122# a_2380_2122# 0.83154f
C92 a_3521_3236# VDD 0.72208f
C93 Vctr a_1267_4350# 0.19047f
C94 a_2907_4350# a_1267_4350# 0.37517f
C95 RST a_1267_4350# 0.05618f
C96 a_2907_1008# a_3009_1530# 0.21534f
C97 a_1369_5986# VDD 0.22773f
C98 a_3521_4350# VDD 0.72208f
C99 RST a_1839_2122# 1.03896f
C100 Vref a_1267_5464# 0.01098f
C101 a_1839_5464# a_1941_4350# 0.01707f
C102 a_1941_3758# VDD 0.22763f
C103 a_3521_2122# a_3317_2122# 0.40843f
C104 a_1267_2122# a_2584_2122# 0.71176f
C105 a_4437_1315# a_4437_1103# 0.01085f
C106 Vctr a_1267_5464# 0.18515f
C107 a_1941_2122# a_1839_3236# 0.01698f
C108 a_1369_4350# a_1267_4350# 0.22323f
C109 a_1941_4350# a_1839_4350# 0.21287f
C110 a_4053_5986# a_4053_5771# 0.01056f
C111 a_1267_2122# a_1369_2122# 0.22361f
C112 a_2380_3236# VDD 0.52925f
C113 RST a_1267_5464# 0.11038f
C114 a_3009_3236# a_2584_3236# 0.04719f
C115 a_4437_3543# a_4437_3331# 0.01085f
C116 a_3317_3236# a_2907_3236# 0.14521f
C117 a_2380_2122# VDD 0.52925f
C118 a_2380_1008# a_3317_1008# 0.0172f
C119 VOUT a_3521_2122# 0.11264f
C120 a_4053_4865# a_4053_4650# 0.01056f
C121 a_2584_1008# a_2805_1530# 0.04511f
C122 a_4437_1530# a_4437_1315# 0.01056f
C123 VOUT a_3521_1008# 0.11072f
C124 a_2584_4350# VDD 0.47245f
C125 a_2584_3236# a_2380_3236# 0.83154f
C126 a_1369_4350# a_1267_5464# 0.01956f
C127 a_1267_3236# a_2907_3236# 0.37587f
C128 a_2584_4350# a_3009_5072# 0.04702f
C129 a_2805_5986# a_2584_5464# 0.04511f
C130 a_3009_5986# a_1267_5464# 0.02044f
C131 Vref a_1839_3236# 0.21424f
C132 a_4053_2422# a_4053_2210# 0.01085f
C133 a_3317_1008# a_3317_2122# 0.01806f
C134 a_4821_5771# a_4821_5986# 0.01056f
C135 a_2584_5464# a_2380_5464# 0.77156f
C136 RST a_1369_1008# 0.01498f
C137 a_1267_5464# a_2907_5464# 0.37961f
C138 a_1267_2122# VDD 0.81559f
C139 a_4053_4438# a_4053_4650# 0.01085f
C140 a_2584_1008# a_3009_1008# 0.04719f
C141 a_3521_2122# a_3521_3236# 0.02864f
C142 RST a_1839_3236# 0.74483f
C143 a_1941_5986# VDD 0.22773f
C144 a_2380_1008# a_2584_1008# 0.83117f
C145 VDD a_2584_5464# 0.47226f
C146 a_1369_5986# a_1267_5464# 0.21767f
C147 a_4053_1742# VDD 0.01146f
C148 a_1369_2122# a_1267_3236# 0.01878f
C149 a_1839_2122# a_2380_2122# 0.19576f
C150 a_2584_4350# a_1267_4350# 0.70219f
C151 a_2380_4350# a_1839_4350# 0.19537f
C152 a_3317_3236# VDD 0.71605f
C153 a_3009_2844# a_2907_2122# 0.09917f
C154 a_1839_2122# a_1267_2122# 0.86515f
C155 a_1839_5464# a_2380_5464# 0.20354f
C156 a_2907_4350# a_2805_4350# 0.20304f
C157 a_1369_1530# VDD 0.22773f
C158 a_4821_6198# a_4821_5986# 0.01085f
C159 a_1267_3236# VDD 0.78139f
C160 a_2805_3236# a_1267_3236# 0.01675f
C161 a_3317_4350# a_3317_5464# 0.03047f
C162 a_2380_1008# a_3009_1008# 0.01182f
C163 a_1369_3758# a_1267_3236# 0.2172f
C164 a_1941_3758# a_1839_3236# 0.21415f
C165 a_2805_2122# a_2907_2122# 0.20304f
C166 a_3009_2844# a_2584_2122# 0.04719f
C167 a_1839_5464# VDD 0.70481f
C168 a_4437_6198# a_4437_5986# 0.01085f
C169 a_1839_3236# a_2380_3236# 0.20529f
C170 a_1267_3236# a_2584_3236# 0.71451f
C171 a_1941_5986# a_1267_5464# 0.01376f
C172 a_2907_1008# a_2907_2122# 0.02097f
C173 a_1839_4350# VDD 0.73456f
C174 a_3521_5464# a_3317_5464# 0.40843f
C175 a_1267_4350# a_2805_5072# 0.01675f
C176 a_1267_5464# a_2584_5464# 0.678f
C177 a_3009_2122# a_1267_2122# 0.01951f
C178 a_2805_2122# a_2584_2122# 0.04511f
C179 a_4821_6198# VDD 0.01275f
C180 a_1267_2122# a_1369_1008# 0.01488f
C181 a_1839_2122# a_1941_1008# 0.01612f
C182 Vctr Vref 0.10902f
C183 a_3009_4350# VDD 0.22744f
C184 a_3009_5464# a_2907_5464# 0.0992f
C185 a_1267_4350# a_1267_3236# 0.47286f
C186 RST Vref 0.10824f
C187 a_1839_2122# a_1267_3236# 0.01066f
C188 a_4053_3331# a_4053_3543# 0.01085f
C189 a_3009_1530# VDD 0.22744f
C190 RST Vctr 3.75625f
C191 a_2380_4350# a_3317_4350# 0.0172f
C192 a_4821_3970# VDD 0.01146f
C193 a_2805_2122# VDD 0.22722f
C194 a_1839_4350# a_1267_4350# 0.57006f
C195 a_4053_5559# a_4053_5771# 0.01085f
C196 a_1839_5464# a_1267_5464# 0.91449f
C197 a_2584_4350# a_2805_4350# 0.04511f
C198 a_2907_1008# VDD 0.18145f
C199 a_3009_4350# a_1267_4350# 0.01987f
C200 a_1941_3236# a_1839_3236# 0.10389f
C201 a_2907_4350# a_2907_5464# 0.01112f
C202 a_1369_3236# a_1267_3236# 0.1037f
C203 a_2907_1008# a_2805_1008# 0.09917f
C204 a_1839_4350# a_1267_5464# 0.01073f
C205 a_4821_2849# a_4821_2637# 0.01085f
C206 a_2805_2844# a_1267_2122# 0.01675f
C207 a_2805_3758# a_2907_3236# 0.20304f
C208 a_1839_5464# a_1941_5072# 0.02347f
C209 a_4821_5771# a_4821_5559# 0.01085f
C210 a_1839_3236# a_1267_3236# 0.8335f
C211 a_3317_4350# VDD 0.71605f
C212 a_2907_4350# a_3521_4350# 0.01245f
C213 VOUT a_3521_3236# 0.11264f
C214 a_4053_1315# a_4053_1103# 0.01085f
C215 a_3009_5986# a_2907_5464# 0.21534f
C216 a_1839_4350# a_1941_5072# 0.09921f
C217 a_1941_2122# a_1267_2122# 0.01432f
C218 a_4821_2210# VDD 0.01146f
C219 a_2907_2122# a_2907_3236# 0.01112f
C220 a_2380_5464# a_3317_5464# 0.0172f
C221 VOUT a_3521_4350# 0.11264f
C222 a_2380_2122# a_3317_2122# 0.0172f
C223 a_1941_4350# VDD 0.22773f
C224 a_1839_4350# a_1839_3236# 0.29007f
C225 a_3009_5464# a_2584_5464# 0.04714f
C226 a_3521_5464# VDD 0.71927f
C227 a_4053_1530# a_4053_1315# 0.01056f
C228 VDD a_3317_5464# 0.71387f
C229 Vref a_1267_2122# 0.04432f
C230 a_4437_4438# VDD 0.01146f
C231 a_2584_4350# a_2907_4350# 0.33207f
C232 a_2584_2122# a_2907_2122# 0.34325f
C233 a_1267_2122# a_3317_2122# 0.01031f
C234 a_4053_3970# VDD 0.01146f
C235 a_3521_3236# a_3521_4350# 0.03719f
C236 Vctr a_1267_2122# 0.18113f
C237 a_3317_4350# a_1267_4350# 0.01067f
C238 a_2907_1008# a_3521_1008# 0.01245f
C239 RST a_1267_2122# 0.06849f
C240 a_2805_3758# VDD 0.22722f
C241 a_1941_4350# a_1267_4350# 0.01706f
C242 a_2380_4350# a_2380_5464# 0.03435f
C243 a_2907_3236# VDD 0.18158f
C244 a_3009_3236# a_2380_3236# 0.01182f
C245 a_2805_3236# a_2907_3236# 0.09917f
C246 a_2805_3758# a_2584_3236# 0.04511f
C247 a_3009_3758# a_1267_3236# 0.02006f
C248 a_2907_2122# VDD 0.18194f
C249 a_2907_1008# a_3317_1008# 0.14521f
C250 a_3317_3236# a_3317_2122# 0.03047f
C251 a_2380_4350# VDD 0.52954f
C252 a_2380_4350# a_3009_5072# 0.01182f
C253 a_2584_3236# a_2907_3236# 0.34325f
C254 a_2907_4350# a_2805_5072# 0.09917f
C255 Vref a_1267_3236# 0.05475f
C256 a_4053_2210# VDD 0.01146f
C257 a_2584_5464# a_2907_5464# 0.3331f
C258 a_1267_5464# a_3317_5464# 0.01121f
C259 a_2380_2122# a_2380_3236# 0.03435f
C260 a_2584_2122# VDD 0.47283f
C261 Vctr a_1267_3236# 0.197f
C262 a_4053_3543# a_4053_3758# 0.01056f
C263 a_1369_2122# VDD 0.22773f
C264 a_1839_5464# Vref 0.18656f
C265 a_2805_5464# a_1267_5464# 0.01675f
C266 RST a_1267_3236# 0.14058f
C267 a_2805_5986# VDD 0.22722f
C268 a_2907_1008# a_2584_1008# 0.3427f
C269 VDD a_2380_5464# 0.52864f
C270 a_4821_1742# a_4821_1530# 0.01085f
C271 Vref a_1839_4350# 0.17487f
C272 a_2584_2122# a_2584_3236# 0.07395f
C273 a_4437_5771# a_4437_5986# 0.01056f
C274 a_4053_3970# a_4053_3758# 0.01085f
C275 a_4437_1742# VDD 0.01146f
C276 a_1839_5464# RST 0.81032f
C277 a_1839_2122# a_2907_2122# 0.01463f
C278 a_1267_2122# a_2380_2122# 0.624f
C279 a_2907_4350# a_1839_4350# 0.01489f
C280 a_2380_4350# a_1267_4350# 0.63385f
C281 a_3317_3236# a_3521_3236# 0.40843f
C282 RST a_1839_4350# 1.10723f
C283 a_2907_1008# a_2805_1530# 0.20304f
C284 a_1369_3758# VDD 0.22773f
C285 a_3521_2122# a_2907_2122# 0.01245f
C286 a_1839_2122# a_2584_2122# 0.20131f
C287 a_1839_5464# a_2907_5464# 0.01075f
C288 a_2907_4350# a_3009_4350# 0.21534f
C289 a_4821_2422# a_4821_2637# 0.01056f
C290 a_1941_1530# VDD 0.22773f
C291 a_2584_4350# a_2584_5464# 0.07395f
C292 a_2584_3236# VDD 0.4728f
C293 a_2907_1008# a_3009_1008# 0.09917f
C294 a_2805_3236# a_2584_3236# 0.01463f
C295 a_1941_3758# a_1267_3236# 0.01308f
C296 a_3009_2122# a_2907_2122# 0.21534f
C297 a_3317_3236# a_2380_3236# 0.0172f
C298 a_1839_5464# a_1941_5464# 0.1072f
C299 a_2380_1008# a_2907_1008# 0.19738f
C300 a_4437_2849# a_4437_2637# 0.01085f
C301 a_2584_4350# a_2805_5072# 0.01463f
C302 a_1267_3236# a_2380_3236# 0.59629f
C303 a_1839_3236# a_2907_3236# 0.01582f
C304 a_4821_3758# a_4821_3543# 0.01056f
C305 a_1267_4350# VDD 0.92451f
C306 a_1267_5464# a_2380_5464# 0.63065f
C307 a_1839_2122# VDD 0.7215f
C308 a_1369_3758# a_1267_4350# 0.03168f
C309 a_1941_3758# a_1839_4350# 0.02669f
C310 a_4437_2422# a_4437_2637# 0.01056f
C311 a_4821_3758# a_4821_3970# 0.01085f
C312 a_1369_5464# a_1267_5464# 0.10698f
C313 a_1941_1530# a_1839_2122# 0.02756f
C314 a_1369_1530# a_1267_2122# 0.03293f
C315 a_3521_2122# VDD 0.72208f
C316 VDD a_1267_5464# 0.76636f
C317 a_1267_2122# a_1267_3236# 0.229f
C318 a_4437_6198# VDD 0.01222f
C319 a_3521_1008# VDD 0.72205f
C320 a_2907_4350# a_3317_4350# 0.14521f
C321 a_2584_4350# a_1839_4350# 0.20139f
C322 a_3009_2122# VDD 0.22744f
C323 Vref VSS 1.97944f
C324 Vctr VSS 1.95388f
C325 RST VSS 3.11417f
C326 VOUT VSS 3.7955f
C327 VDD VSS 7.77733f
C328 a_4821_1103# VSS 0.07983f $ **FLOATING
C329 a_4437_1103# VSS 0.07827f $ **FLOATING
C330 a_4053_1103# VSS 0.07904f $ **FLOATING
C331 a_3009_1008# VSS 0.1325f
C332 a_2805_1008# VSS 0.1338f
C333 a_1941_1008# VSS 0.13359f
C334 a_1369_1008# VSS 0.13359f
C335 a_4821_1315# VSS 0.0645f $ **FLOATING
C336 a_4437_1315# VSS 0.04587f $ **FLOATING
C337 a_4053_1315# VSS 0.0637f $ **FLOATING
C338 a_4821_1530# VSS 0.06277f $ **FLOATING
C339 a_4437_1530# VSS 0.04472f $ **FLOATING
C340 a_4053_1530# VSS 0.06272f $ **FLOATING
C341 a_4821_1742# VSS 0.06281f $ **FLOATING
C342 a_4437_1742# VSS 0.06224f $ **FLOATING
C343 a_4053_1742# VSS 0.06276f $ **FLOATING
C344 a_3521_1008# VSS 1.1781f
C345 a_3009_1530# VSS 0.01316f
C346 a_2805_1530# VSS 0.01208f
C347 a_1941_1530# VSS 0.01246f
C348 a_1369_1530# VSS 0.0124f
C349 a_3317_1008# VSS 1.58786f
C350 a_2907_1008# VSS 0.59159f
C351 a_2380_1008# VSS 0.84951f
C352 a_2584_1008# VSS 0.81658f
C353 a_4821_2210# VSS 0.06281f $ **FLOATING
C354 a_4437_2210# VSS 0.06224f $ **FLOATING
C355 a_4053_2210# VSS 0.06276f $ **FLOATING
C356 a_4821_2422# VSS 0.06277f $ **FLOATING
C357 a_4437_2422# VSS 0.04472f $ **FLOATING
C358 a_4053_2422# VSS 0.06272f $ **FLOATING
C359 a_3009_2122# VSS 0.01316f
C360 a_2805_2122# VSS 0.01208f
C361 a_1941_2122# VSS 0.01249f
C362 a_1369_2122# VSS 0.01243f
C363 a_4821_2637# VSS 0.06338f $ **FLOATING
C364 a_4437_2637# VSS 0.04522f $ **FLOATING
C365 a_4053_2637# VSS 0.06332f $ **FLOATING
C366 a_4821_2849# VSS 0.07459f $ **FLOATING
C367 a_4437_2849# VSS 0.0735f $ **FLOATING
C368 a_4053_2849# VSS 0.07453f $ **FLOATING
C369 a_3521_2122# VSS 1.13463f
C370 a_3009_2844# VSS 0.1325f
C371 a_2805_2844# VSS 0.1338f
C372 a_1941_2844# VSS 0.13359f
C373 a_1369_2844# VSS 0.13359f
C374 a_3317_2122# VSS 1.55102f
C375 a_2907_2122# VSS 0.57945f
C376 a_2380_2122# VSS 0.80986f
C377 a_2584_2122# VSS 0.74975f
C378 a_1267_2122# VSS 1.6756f
C379 a_1839_2122# VSS 1.61958f
C380 a_4821_3331# VSS 0.07459f $ **FLOATING
C381 a_4437_3331# VSS 0.0735f $ **FLOATING
C382 a_4053_3331# VSS 0.07453f $ **FLOATING
C383 a_3009_3236# VSS 0.1325f
C384 a_2805_3236# VSS 0.1338f
C385 a_1941_3236# VSS 0.13359f
C386 a_1369_3236# VSS 0.13359f
C387 a_4821_3543# VSS 0.06338f $ **FLOATING
C388 a_4437_3543# VSS 0.04522f $ **FLOATING
C389 a_4053_3543# VSS 0.06332f $ **FLOATING
C390 a_4821_3758# VSS 0.06277f $ **FLOATING
C391 a_4437_3758# VSS 0.04472f $ **FLOATING
C392 a_4053_3758# VSS 0.06272f $ **FLOATING
C393 a_4821_3970# VSS 0.06281f $ **FLOATING
C394 a_4437_3970# VSS 0.06224f $ **FLOATING
C395 a_4053_3970# VSS 0.06276f $ **FLOATING
C396 a_3521_3236# VSS 1.13463f
C397 a_3009_3758# VSS 0.01316f
C398 a_2805_3758# VSS 0.01208f
C399 a_1941_3758# VSS 0.01246f
C400 a_1369_3758# VSS 0.01232f
C401 a_3317_3236# VSS 1.55102f
C402 a_2907_3236# VSS 0.57894f
C403 a_2380_3236# VSS 0.80973f
C404 a_2584_3236# VSS 0.74966f
C405 a_1267_3236# VSS 1.65886f
C406 a_1839_3236# VSS 1.6092f
C407 a_4821_4438# VSS 0.06281f $ **FLOATING
C408 a_4437_4438# VSS 0.06224f $ **FLOATING
C409 a_4053_4438# VSS 0.06276f $ **FLOATING
C410 a_4821_4650# VSS 0.06277f $ **FLOATING
C411 a_4437_4650# VSS 0.04472f $ **FLOATING
C412 a_4053_4650# VSS 0.06272f $ **FLOATING
C413 a_3009_4350# VSS 0.01316f
C414 a_2805_4350# VSS 0.01208f
C415 a_1941_4350# VSS 0.01249f
C416 a_1369_4350# VSS 0.01249f
C417 a_4821_4865# VSS 0.06338f $ **FLOATING
C418 a_4437_4865# VSS 0.04522f $ **FLOATING
C419 a_4053_4865# VSS 0.06332f $ **FLOATING
C420 a_4821_5077# VSS 0.07459f $ **FLOATING
C421 a_4437_5077# VSS 0.0735f $ **FLOATING
C422 a_4053_5077# VSS 0.07453f $ **FLOATING
C423 a_3521_4350# VSS 1.13463f
C424 a_3009_5072# VSS 0.1325f
C425 a_2805_5072# VSS 0.1338f
C426 a_1941_5072# VSS 0.13359f
C427 a_1369_5072# VSS 0.13359f
C428 a_3317_4350# VSS 1.55102f
C429 a_2907_4350# VSS 0.58045f
C430 a_2380_4350# VSS 0.81089f
C431 a_2584_4350# VSS 0.74943f
C432 a_1267_4350# VSS 1.69515f
C433 a_1839_4350# VSS 1.60298f
C434 a_4821_5559# VSS 0.07459f $ **FLOATING
C435 a_4437_5559# VSS 0.0735f $ **FLOATING
C436 a_4053_5559# VSS 0.07453f $ **FLOATING
C437 a_3009_5464# VSS 0.1325f
C438 a_2805_5464# VSS 0.1338f
C439 a_1941_5464# VSS 0.13359f
C440 a_1369_5464# VSS 0.13359f
C441 a_4821_5771# VSS 0.06338f $ **FLOATING
C442 a_4437_5771# VSS 0.04522f $ **FLOATING
C443 a_4053_5771# VSS 0.06332f $ **FLOATING
C444 a_4821_5986# VSS 0.06277f $ **FLOATING
C445 a_4437_5986# VSS 0.04472f $ **FLOATING
C446 a_4053_5986# VSS 0.06272f $ **FLOATING
C447 a_4821_6198# VSS 0.06708f $ **FLOATING
C448 a_4437_6198# VSS 0.06651f $ **FLOATING
C449 a_4053_6198# VSS 0.06703f $ **FLOATING
C450 a_3521_5464# VSS 1.19217f
C451 a_3009_5986# VSS 0.01316f
C452 a_2805_5986# VSS 0.01208f
C453 a_1941_5986# VSS 0.01249f
C454 a_1369_5986# VSS 0.01249f
C455 a_3317_5464# VSS 1.57442f
C456 a_2907_5464# VSS 0.61671f
C457 a_2380_5464# VSS 0.81715f
C458 a_2584_5464# VSS 0.7604f
C459 a_1267_5464# VSS 1.91405f
C460 a_1839_5464# VSS 1.6728f
C461 RST.t1 VSS 0.1622f
C462 RST.t0 VSS 0.29056f
C463 RST.t2 VSS 0.19144f
C464 RST.n0 VSS 2.03879f
C465 RST.t4 VSS 0.19807f
C466 RST.n1 VSS 1.10651f
C467 RST.t5 VSS 0.22559f
C468 RST.n2 VSS 1.2248f
C469 RST.t3 VSS 0.2261f
C470 RST.n3 VSS 1.95697f
C471 RST.n4 VSS 0.49028f
C472 a_917_3663.t5 VSS 0.1985f
C473 a_917_3663.t3 VSS 0.17815f
C474 a_917_3663.n0 VSS 0.79953f
C475 a_917_3663.t4 VSS 0.19934f
C476 a_917_3663.t6 VSS 0.17815f
C477 a_917_3663.n1 VSS 0.80229f
C478 a_917_3663.n2 VSS 0.44572f
C479 a_917_3663.t7 VSS 0.15078f
C480 a_917_3663.n3 VSS 0.27714f
C481 a_917_3663.t2 VSS 0.1482f
C482 a_917_3663.t0 VSS 0.15249f
C483 a_917_3663.n4 VSS 0.27966f
C484 a_917_3663.t1 VSS 0.29005f
C485 a_1267_1008.t1 VSS 0.28187f
C486 a_1267_1008.t4 VSS 0.18516f
C487 a_1267_1008.t3 VSS 0.0837f
C488 a_1267_1008.n0 VSS 0.14597f
C489 a_1267_1008.t5 VSS 0.25186f
C490 a_1267_1008.n1 VSS 0.4767f
C491 a_1267_1008.n2 VSS 0.46461f
C492 a_1267_1008.t2 VSS 1.00784f
C493 a_1267_1008.n3 VSS 1.35299f
C494 a_1267_1008.t0 VSS 0.14931f
C495 Vref.t5 VSS 0.33959f
C496 Vref.t0 VSS 0.36617f
C497 Vref.t1 VSS 0.33401f
C498 Vref.n0 VSS 1.92496f
C499 Vref.t2 VSS 0.33401f
C500 Vref.n1 VSS 1.32209f
C501 Vref.t3 VSS 0.33401f
C502 Vref.n2 VSS 0.64651f
C503 Vref.t4 VSS 0.41402f
C504 Vref.n3 VSS 2.59825f
C505 Vref.n4 VSS 0.83767f
C506 Vctr.t4 VSS 0.30638f
C507 Vctr.t5 VSS 0.32333f
C508 Vctr.t0 VSS 0.29504f
C509 Vctr.n0 VSS 1.63789f
C510 Vctr.t3 VSS 0.37339f
C511 Vctr.t2 VSS 0.29504f
C512 Vctr.n1 VSS 1.95598f
C513 Vctr.t1 VSS 0.29504f
C514 Vctr.n2 VSS 0.55185f
C515 Vctr.n3 VSS 1.24123f
C516 Vctr.n4 VSS 0.58123f
C517 a_917_2086.t5 VSS 0.21359f
C518 a_917_2086.t3 VSS 0.19196f
C519 a_917_2086.n0 VSS 0.94594f
C520 a_917_2086.t7 VSS 0.19267f
C521 a_917_2086.n1 VSS 0.61666f
C522 a_917_2086.t6 VSS 0.19267f
C523 a_917_2086.t4 VSS 0.21454f
C524 a_917_2086.n2 VSS 1.35218f
C525 a_917_2086.t2 VSS 0.31382f
C526 a_917_2086.t1 VSS 0.16519f
C527 a_917_2086.n3 VSS 0.54056f
C528 a_917_2086.t0 VSS 0.16021f
C529 a_1839_1008.t1 VSS 0.30908f
C530 a_1839_1008.t4 VSS 0.26128f
C531 a_1839_1008.t3 VSS 0.27295f
C532 a_1839_1008.n0 VSS 0.5f
C533 a_1839_1008.n1 VSS 0.15774f
C534 a_1839_1008.t2 VSS 1.431f
C535 a_1839_1008.n2 VSS 1.30613f
C536 a_1839_1008.t0 VSS 0.16182f
C537 VOUT.t1 VSS 0.0523f
C538 VOUT.t2 VSS 0.05249f
C539 VOUT.n0 VSS 0.21761f
C540 VOUT.t0 VSS 0.05249f
C541 VOUT.t8 VSS 0.0523f
C542 VOUT.n1 VSS 0.19221f
C543 VOUT.n2 VSS 0.8879f
C544 VOUT.t6 VSS 0.0523f
C545 VOUT.t9 VSS 0.05249f
C546 VOUT.n3 VSS 0.19221f
C547 VOUT.n4 VSS 0.58406f
C548 VOUT.t3 VSS 0.05249f
C549 VOUT.t7 VSS 0.0523f
C550 VOUT.n5 VSS 0.11821f
C551 VOUT.n6 VSS 0.79211f
C552 VOUT.t5 VSS 0.0523f
C553 VOUT.t4 VSS 0.05249f
C554 VOUT.n7 VSS 0.11821f
C555 VDD.n9 VSS 0.01185f
C556 VDD.n15 VSS 0.01128f
C557 VDD.n16 VSS 0.01073f
C558 VDD.n18 VSS 0.01016f
C559 VDD.n20 VSS 0.01182f
C560 VDD.n21 VSS 0.01062f
C561 VDD.n24 VSS 0.0102f
C562 VDD.n26 VSS 0.01959f
C563 VDD.t6 VSS 0.5684f
C564 VDD.n27 VSS 0.0657f
C565 VDD.n51 VSS 0.01621f
C566 VDD.n52 VSS 0.03087f
C567 VDD.n53 VSS 0.01959f
C568 VDD.n62 VSS 0.01185f
C569 VDD.n68 VSS 0.01128f
C570 VDD.n69 VSS 0.01073f
C571 VDD.n71 VSS 0.01016f
C572 VDD.n73 VSS 0.01182f
C573 VDD.n74 VSS 0.01062f
C574 VDD.n77 VSS 0.0102f
C575 VDD.t0 VSS 1.01056f
C576 VDD.n79 VSS 0.06548f
C577 VDD.n80 VSS 0.02794f
C578 VDD.n81 VSS 0.04968f
C579 VDD.n82 VSS 0.03096f
C580 VDD.t3 VSS 1.01169f
C581 VDD.n83 VSS 0.07124f
.ends
